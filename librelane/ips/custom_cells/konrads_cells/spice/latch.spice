* NGSPICE file created from latch_rcx.ext - technology: ihp-sg13g2

.subckt latch_rcx D VSS VDD GATE
X0 a_388_448# D.t0 a_286_162# VDD.t0 sg13_lv_pmos ad=75.59999f pd=1.02u as=0.1596p ps=1.22u w=0.84u l=0.13u
X1 VDD.t1 a_28_162# a_388_448# VDD.t0 sg13_lv_pmos ad=0.269p pd=1.77u as=75.59999f ps=1.02u w=0.84u l=0.13u
X2 Q a_286_162# VSS.t2 VSS.t4 sg13_lv_nmos ad=0.2992p pd=2.44u as=0.19525p ps=1.35u w=0.88u l=0.13u
X3 a_224_162# a_28_162# VSS.t1 VSS.t0 sg13_lv_nmos ad=49.5f pd=0.73u as=0.1045p ps=0.93u w=0.55u l=0.13u
X4 a_286_162# Q a_224_162# VSS.t0 sg13_lv_nmos ad=0.1045p pd=0.93u as=49.5f ps=0.73u w=0.55u l=0.13u
X5 VDD.t2 GATE.t0 a_28_162# VDD.t0 sg13_lv_pmos ad=0.1596p pd=1.22u as=0.2856p ps=2.36u w=0.84u l=0.13u
X6 a_388_162# D.t0 a_286_162# VSS.t0 sg13_lv_nmos ad=49.5f pd=0.73u as=0.1045p ps=0.93u w=0.55u l=0.13u
X7 VSS.t2 GATE.t0 a_388_162# VSS.t0 sg13_lv_nmos ad=0.19525p pd=1.35u as=49.5f ps=0.73u w=0.55u l=0.13u
X8 VSS.t1 GATE.t0 a_28_162# VSS.t0 sg13_lv_nmos ad=0.1045p pd=0.93u as=0.187p ps=1.78u w=0.55u l=0.13u
X9 Q a_286_162# VDD.t1 VDD.t0 sg13_lv_pmos ad=0.4504p pd=3.3u as=0.269p ps=1.77u w=1.3u l=0.13u
X10 a_224_448# GATE.t0 VDD.t2 VDD.t0 sg13_lv_pmos ad=75.59999f pd=1.02u as=0.1596p ps=1.22u w=0.84u l=0.13u
X11 a_286_162# Q a_224_448# VDD.t0 sg13_lv_pmos ad=0.1596p pd=1.22u as=75.59999f ps=1.02u w=0.84u l=0.13u
R0 GATE GATE.t0 15.0505
R1 D.n0 D.t0 15.1896
R2 D.n0 D 0.161833
R3 D D.n0 0.0520625
R4 VDD.n0 VDD.t2 17.5574
R5 VDD.n1 VDD.t1 8.97831
R6 VDD.n3 VDD.n2 8.47111
R7 VDD.n2 VDD.n1 3.34133
R8 VDD.n2 VDD.t0 2.42907
R9 VDD.n1 VDD.n0 0.303442
R10 VDD VDD.n3 0.120789
R11 VDD.n3 VDD.n0 0.080789
R12 VSS.n4 VSS.t4 718.75
R13 VSS.t4 VSS.t0 128.906
R14 VSS.n9 VSS.t1 17.3601
R15 VSS.n2 VSS.t2 17.2882
R16 VSS.n7 VSS.n6 17.0005
R17 VSS.n5 VSS.n2 8.57339
R18 VSS.n5 VSS.n4 8.50175
R19 VSS.n4 VSS.n3 8.501
R20 VSS.n10 VSS.n0 8.47161
R21 VSS.n8 VSS.n1 8.47111
R22 VSS.n4 VSS.n0 5.66767
R23 VSS.n8 VSS.n7 0.180789
R24 VSS.n9 VSS.n8 0.160789
R25 VSS VSS.n10 0.120789
R26 VSS.n10 VSS.n9 0.080789
R27 VSS.n7 VSS.n2 0.078
R28 VSS.n6 VSS.n5 0.00124911
R29 VSS.n6 VSS.n3 0.001
R30 VSS.n1 VSS.n0 0.001
R31 VSS.n3 VSS.n1 0.001
C0 D a_388_448# 0
C1 Q a_28_162# 0.3232f
C2 D a_286_162# 0.17754f
C3 a_224_448# a_286_162# 0
C4 VDD GATE 0.12043f
C5 a_388_162# a_286_162# 0.00199f
C6 a_28_162# a_388_448# 0.00305f
C7 D GATE 0.04509f
C8 Q a_286_162# 0.65312f
C9 a_28_162# a_286_162# 0.36186f
C10 D VDD 0.47095f
C11 a_388_448# a_286_162# 0.00817f
C12 Q GATE 0.06521f
C13 D a_224_448# 0.00587f
C14 a_28_162# GATE 0.19379f
C15 Q VDD 0.17377f
C16 a_28_162# VDD 0.21149f
C17 Q a_224_162# 0.00465f
C18 D Q 0.07676f
C19 a_28_162# a_224_162# 0
C20 D a_28_162# 0.12678f
C21 Q a_224_448# 0
C22 GATE a_286_162# 0.01657f
C23 VDD a_388_448# 0.00173f
C24 a_28_162# a_224_448# 0.00395f
C25 VDD a_286_162# 0.21907f
C26 a_388_162# Q 0.00595f
C27 GATE VSS 0.64494f
C28 D VSS 0.14219f
C29 VDD VSS 0.17439f
C30 a_224_162# VSS 0.00158f
C31 a_224_448# VSS 0
C32 a_28_162# VSS 0.16864f
C33 a_286_162# VSS 0.10071f
C34 Q VSS 0.64632f
C35 VDD.t2 VSS 0.02927f
C36 VDD.n0 VSS 0.05213f
C37 VDD.t1 VSS 0.05029f
C38 VDD.n1 VSS 0.08583f
C39 VDD.t0 VSS 0.86603f
C40 VDD.n2 VSS 0.0919f
C41 VDD.n3 VSS 0.00998f
C42 D.t0 VSS 0.43748f
C43 D.n0 VSS 0.3624f
C44 GATE.t0 VSS 0.36554f
.ends
