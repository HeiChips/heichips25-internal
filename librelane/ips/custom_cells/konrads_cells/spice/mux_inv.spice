* NGSPICE file created from mux_inv_rcx.ext - technology: ihp-sg13g2

.subckt mux_inv_rcx X VDD VSS SEL B A
X0 a_228_96# a_32_96# VSS.t3 VSS.t6 sg13_lv_nmos ad=61.19999f pd=0.86u as=0.1292p ps=1.06u w=0.68u l=0.13u
X1 X.t0 A.t0 a_228_96# VSS.t4 sg13_lv_nmos ad=0.1292p pd=1.06u as=61.19999f ps=0.86u w=0.68u l=0.13u
X2 VSS.t3 SEL.t1 a_32_96# VSS.t2 sg13_lv_nmos ad=0.1292p pd=1.06u as=0.2312p ps=2.04u w=0.68u l=0.13u
X3 X.t1 A.t0 a_228_456# VDD.t0 sg13_lv_pmos ad=0.1938p pd=1.4u as=91.8f ps=1.2u w=1.02u l=0.13u
X4 a_392_456# B.t0 X.t1 VDD.t0 sg13_lv_pmos ad=91.8f pd=1.2u as=0.1938p ps=1.4u w=1.02u l=0.13u
X5 VDD.t1 SEL.t1 a_32_96# VDD.t0 sg13_lv_pmos ad=0.1938p pd=1.4u as=0.3468p ps=2.72u w=1.02u l=0.13u
X6 VDD.t3 a_32_96# a_392_456# VDD.t0 sg13_lv_pmos ad=0.3468p pd=2.72u as=91.8f ps=1.2u w=1.02u l=0.13u
X7 a_228_456# SEL.t1 VDD.t1 VDD.t0 sg13_lv_pmos ad=91.8f pd=1.2u as=0.1938p ps=1.4u w=1.02u l=0.13u
X8 VSS.t1 SEL.t0 a_392_96# VSS.t0 sg13_lv_nmos ad=0.2312p pd=2.04u as=61.19999f ps=0.86u w=0.68u l=0.13u
X9 a_392_96# B.t0 X.t0 VSS.t5 sg13_lv_nmos ad=61.19999f pd=0.86u as=0.1292p ps=1.06u w=0.68u l=0.13u
R0 X.n0 X.t0 19.4732
R1 X.n0 X.t1 8.5005
R2 X X.n0 0.1083
R3 B B.t0 15.0931
R4 A A.t0 15.0738
R5 SEL.n0 SEL.t0 15.8707
R6 SEL.n0 SEL.t1 15.0005
R7 SEL SEL.n0 0.0605
R8 VDD.n1 VDD.t3 17.3206
R9 VDD.n0 VDD.t1 8.71077
R10 VDD.n3 VDD.n2 8.47111
R11 VDD.n2 VDD.n1 4.18824
R12 VDD.n2 VDD.t0 2.83383
R13 VDD.n1 VDD.n0 0.263458
R14 VDD VDD.n3 0.120789
R15 VDD.n3 VDD.n0 0.085789
R16 VSS.n2 VSS.t6 532.468
R17 VSS.n3 VSS.t4 438.12
R18 VSS.t5 VSS.n0 395.087
R19 VSS.n3 VSS.t5 319.308
R20 VSS.t4 VSS.n1 274.752
R21 VSS.t6 VSS.n1 185.644
R22 VSS.n2 VSS.t2 154.008
R23 VSS.n0 VSS.t0 59.3312
R24 VSS.n5 VSS.t1 17.3199
R25 VSS.n4 VSS.n1 17.0005
R26 VSS.n4 VSS.n3 17.0005
R27 VSS.n4 VSS.n0 15.0929
R28 VSS.n4 VSS.n2 11.3744
R29 VSS.n6 VSS.t3 8.71077
R30 VSS.n7 VSS.n4 8.47111
R31 VSS.n5 VSS.n4 4.18824
R32 VSS.n6 VSS.n5 0.264225
R33 VSS VSS.n7 0.120789
R34 VSS.n7 VSS.n6 0.085789
C0 SEL X 0.17956f
C1 B a_32_96# 0.09631f
C2 a_228_96# SEL 0.00193f
C3 a_228_456# a_32_96# 0.00479f
C4 A a_32_96# 0.19553f
C5 a_392_456# SEL 0
C6 B VDD 0.05309f
C7 a_228_96# X 0.00146f
C8 a_228_456# VDD 0.00121f
C9 B a_392_96# 0
C10 A VDD 0.06308f
C11 a_392_456# X 0.00767f
C12 B SEL 0.21344f
C13 a_32_96# VDD 0.32929f
C14 a_228_456# SEL 0
C15 A SEL 0.22614f
C16 B X 0.1452f
C17 a_228_96# B 0.00198f
C18 a_32_96# SEL 0.5126f
C19 a_228_456# X 0.00695f
C20 A X 0.01218f
C21 SEL VDD 0.14703f
C22 a_32_96# X 0.38987f
C23 a_228_96# a_32_96# 0
C24 SEL a_392_96# 0
C25 VDD X 0.35215f
C26 a_392_456# a_32_96# 0.00432f
C27 a_392_96# X 0.00682f
C28 B A 0.08583f
C29 a_392_456# VDD 0
C30 X VSS 0.37806f
C31 B VSS 0.35736f
C32 A VSS 0.19745f
C33 SEL VSS 0.28522f
C34 VDD VSS 0.15592f
C35 a_392_96# VSS 0
C36 a_228_96# VSS 0.00579f
C37 a_32_96# VSS 0.39836f
C38 VDD.t1 VSS 0.03258f
C39 VDD.n0 VSS 0.05027f
C40 VDD.t3 VSS 0.0293f
C41 VDD.n1 VSS 0.06231f
C42 VDD.t0 VSS 0.67965f
C43 VDD.n2 VSS 0.07195f
C44 VDD.n3 VSS 0.00969f
C45 SEL.t0 VSS 0.17222f
C46 SEL.t1 VSS 0.58308f
C47 SEL.n0 VSS 0.44548f
C48 A.t0 VSS 0.44494f
C49 B.t0 VSS 0.34698f
C50 X.t0 VSS 0.18877f
C51 X.t1 VSS 0.24196f
C52 X.n0 VSS 0.59466f
.ends
