* NGSPICE file created from heichips25_internal.ext - technology: ihp-sg13g2

* Black-box entry subcircuit for sg13g2_decap_8 abstract view
.subckt sg13g2_decap_8 VDD VSS
.ends

* Black-box entry subcircuit for sg13g2_fill_2 abstract view
.subckt sg13g2_fill_2 VDD VSS
.ends

* Black-box entry subcircuit for sg13g2_dfrbpq_1 abstract view
.subckt sg13g2_dfrbpq_1 Q CLK D RESET_B VDD VSS
.ends

* Black-box entry subcircuit for sg13g2_mux2_1 abstract view
.subckt sg13g2_mux2_1 X A0 A1 S VDD VSS
.ends

* Black-box entry subcircuit for sg13g2_fill_1 abstract view
.subckt sg13g2_fill_1 VDD VSS
.ends

* Black-box entry subcircuit for sg13g2_nand4_1 abstract view
.subckt sg13g2_nand4_1 Y A B C D VDD VSS
.ends

* Black-box entry subcircuit for sg13g2_buf_16 abstract view
.subckt sg13g2_buf_16 X A VDD VSS
.ends

* Black-box entry subcircuit for sg13g2_decap_4 abstract view
.subckt sg13g2_decap_4 VDD VSS
.ends

* Black-box entry subcircuit for sg13g2_buf_1 abstract view
.subckt sg13g2_buf_1 X A VDD VSS
.ends

* Black-box entry subcircuit for sg13g2_nand3b_1 abstract view
.subckt sg13g2_nand3b_1 Y A_N B C VDD VSS
.ends

* Black-box entry subcircuit for sg13g2_and2_1 abstract view
.subckt sg13g2_and2_1 X A B VDD VSS
.ends

* Black-box entry subcircuit for sg13g2_nor2_1 abstract view
.subckt sg13g2_nor2_1 Y A B VDD VSS
.ends

* Black-box entry subcircuit for sg13g2_buf_8 abstract view
.subckt sg13g2_buf_8 X A VDD VSS
.ends

* Black-box entry subcircuit for sg13g2_nand2b_1 abstract view
.subckt sg13g2_nand2b_1 Y A_N B VDD VSS
.ends

* Black-box entry subcircuit for sg13g2_a21oi_1 abstract view
.subckt sg13g2_a21oi_1 Y A1 A2 B1 VDD VSS
.ends

* Black-box entry subcircuit for sg13g2_nor2b_1 abstract view
.subckt sg13g2_nor2b_1 Y A B_N VDD VSS
.ends

* Black-box entry subcircuit for sg13g2_xnor2_1 abstract view
.subckt sg13g2_xnor2_1 Y A B VDD VSS
.ends

* Black-box entry subcircuit for delay_line abstract view
.subckt delay_line VDD VSS clk clk_delayed reset sel[0] sel[1] sel[2] sel[3] trim[0]
+ trim[10] trim[11] trim[12] trim[13] trim[14] trim[15] trim[16] trim[17] trim[18]
+ trim[19] trim[1] trim[20] trim[21] trim[22] trim[23] trim[2] trim[3] trim[4] trim[5]
+ trim[6] trim[7] trim[8] trim[9]
.ends

* Black-box entry subcircuit for sg13g2_dlygate4sd3_1 abstract view
.subckt sg13g2_dlygate4sd3_1 X A VDD VSS
.ends

* Black-box entry subcircuit for sg13g2_inv_4 abstract view
.subckt sg13g2_inv_4 Y A VDD VSS
.ends

* Black-box entry subcircuit for sg13g2_nand2_1 abstract view
.subckt sg13g2_nand2_1 Y A B VDD VSS
.ends

* Black-box entry subcircuit for sg13g2_inv_1 abstract view
.subckt sg13g2_inv_1 Y A VDD VSS
.ends

* Black-box entry subcircuit for sg13g2_xor2_1 abstract view
.subckt sg13g2_xor2_1 X A B VDD VSS
.ends

* Black-box entry subcircuit for sg13g2_nor3_1 abstract view
.subckt sg13g2_nor3_1 Y A B C VDD VSS
.ends

* Black-box entry subcircuit for sg13g2_nand3_1 abstract view
.subckt sg13g2_nand3_1 Y A B C VDD VSS
.ends

* Black-box entry subcircuit for sg13g2_o21ai_1 abstract view
.subckt sg13g2_o21ai_1 Y A1 A2 B1 VDD VSS
.ends

* Black-box entry subcircuit for sg13g2_a22oi_1 abstract view
.subckt sg13g2_a22oi_1 Y A1 A2 B1 B2 VDD VSS
.ends

* Black-box entry subcircuit for sg13g2_or2_1 abstract view
.subckt sg13g2_or2_1 X A B VDD VSS
.ends

* Black-box entry subcircuit for sg13g2_mux4_1 abstract view
.subckt sg13g2_mux4_1 X A0 A1 A2 A3 S0 S1 VDD VSS
.ends

* Black-box entry subcircuit for multimode_dll abstract view
.subckt multimode_dll VDD VSS bias clk0_out clk0_phase_sel[0] clk0_phase_sel[1] clk0_phase_sel[2]
+ clk0_phase_sel[3] clk0_phase_sel[4] clk1_out clk1_phase_sel[0] clk1_phase_sel[1]
+ clk1_phase_sel[2] clk1_phase_sel[3] clk1_phase_sel[4] clk2_out clk2_phase_sel[0]
+ clk2_phase_sel[1] clk2_phase_sel[2] clk2_phase_sel[3] clk2_phase_sel[4] dco enable
+ ext_trim[0] ext_trim[10] ext_trim[11] ext_trim[12] ext_trim[13] ext_trim[14] ext_trim[15]
+ ext_trim[16] ext_trim[17] ext_trim[18] ext_trim[19] ext_trim[1] ext_trim[20] ext_trim[21]
+ ext_trim[22] ext_trim[23] ext_trim[24] ext_trim[25] ext_trim[2] ext_trim[3] ext_trim[4]
+ ext_trim[5] ext_trim[6] ext_trim[7] ext_trim[8] ext_trim[9] f_clk0_divider[0] f_clk0_divider[1]
+ f_clk0_divider[2] f_clk0_divider[3] f_clk0_divider[4] f_clk1_divider[0] f_clk1_divider[1]
+ f_clk1_divider[2] f_clk1_divider[3] f_clk1_divider[4] f_clk2_divider[0] f_clk2_divider[1]
+ f_clk2_divider[2] f_clk2_divider[3] f_clk2_divider[4] f_osc_multiply_factor[0] f_osc_multiply_factor[1]
+ f_osc_multiply_factor[2] f_osc_multiply_factor[3] f_osc_multiply_factor[4] mode_xor[0]
+ mode_xor[1] mode_xor[2] osc osc_out resetb stable
.ends

* Black-box entry subcircuit for SwitchMatrixMultiplexer_inv abstract view
.subckt SwitchMatrixMultiplexer_inv D A VDD B X VSS SEL
.ends

* Black-box entry subcircuit for mux_inv abstract view
.subckt mux_inv X VDD VSS SEL B A
.ends

* Black-box entry subcircuit for latch abstract view
.subckt latch Q D VSS VDD GATE
.ends

* Black-box entry subcircuit for sg13g2_a21o_1 abstract view
.subckt sg13g2_a21o_1 X A1 A2 B1 VDD VSS
.ends

* Black-box entry subcircuit for sg13g2_antennanp abstract view
.subckt sg13g2_antennanp A VDD VSS
.ends

* Black-box entry subcircuit for mux abstract view
.subckt mux VSS VDD X A SEL B
.ends

* Black-box entry subcircuit for SwitchMatrixMultiplexer abstract view
.subckt SwitchMatrixMultiplexer D VSS VDD A B X SEL
.ends

.subckt heichips25_internal VGND VPWR analog_pin0 analog_pin1 analog_pin2 clk ena
+ rst_n ui_in[0] ui_in[1] ui_in[2] ui_in[3] ui_in[4] ui_in[5] ui_in[6] ui_in[7] uio_in[0]
+ uio_in[1] uio_in[2] uio_in[3] uio_in[4] uio_in[5] uio_in[6] uio_in[7] uio_oe[0]
+ uio_oe[1] uio_oe[2] uio_oe[3] uio_oe[4] uio_oe[5] uio_oe[6] uio_oe[7] uio_out[0]
+ uio_out[1] uio_out[2] uio_out[3] uio_out[4] uio_out[5] uio_out[6] uio_out[7] uo_out[0]
+ uo_out[1] uo_out[2] uo_out[3] uo_out[4] uo_out[5] uo_out[6] uo_out[7]
XFILLER_2_505 VPWR VGND sg13g2_decap_8
XFILLER_26_41 VPWR VGND sg13g2_fill_2
X_501_ _501_/Q _513_/CLK _501_/D fanout86/X VPWR VGND sg13g2_dfrbpq_1
X_432_ _597_/D _625_/D _626_/D _436_/S VPWR VGND sg13g2_mux2_1
XFILLER_46_737 VPWR VGND sg13g2_decap_8
XFILLER_10_840 VPWR VGND sg13g2_decap_8
XFILLER_41_464 VPWR VGND sg13g2_fill_1
X_363_ _528_/D _527_/Q _528_/Q _375_/S VPWR VGND sg13g2_mux2_1
X_294_ _295_/B _469_/Q _471_/Q _472_/Q _475_/Q VPWR VGND sg13g2_nand4_1
XFILLER_6_800 VPWR VGND sg13g2_decap_8
XFILLER_6_877 VPWR VGND sg13g2_decap_8
XFILLER_1_593 VPWR VGND sg13g2_decap_8
XFILLER_49_553 VPWR VGND sg13g2_decap_8
XFILLER_44_291 VPWR VGND sg13g2_decap_8
XFILLER_45_770 VPWR VGND sg13g2_decap_8
XFILLER_36_770 VPWR VGND sg13g2_decap_8
XFILLER_7_608 VPWR VGND sg13g2_decap_8
XFILLER_2_379 VPWR VGND sg13g2_decap_8
XFILLER_3_814 VPWR VGND sg13g2_decap_8
XFILLER_27_770 VPWR VGND sg13g2_decap_8
XFILLER_42_751 VPWR VGND sg13g2_decap_8
X_415_ _580_/D _579_/Q _580_/Q _427_/S VPWR VGND sg13g2_mux2_1
X_346_ _511_/D _510_/Q _511_/Q _416_/S VPWR VGND sg13g2_mux2_1
XFILLER_46_578 VPWR VGND sg13g2_decap_8
X_277_ _633_/D _611_/Q _625_/Q _278_/S VPWR VGND sg13g2_mux2_1
XFILLER_6_674 VPWR VGND sg13g2_decap_8
XFILLER_49_350 VPWR VGND sg13g2_decap_8
XFILLER_18_770 VPWR VGND sg13g2_decap_8
XFILLER_33_762 VPWR VGND sg13g2_decap_8
XFILLER_0_839 VPWR VGND sg13g2_decap_8
XFILLER_12_924 VPWR VGND sg13g2_decap_8
XFILLER_24_784 VPWR VGND sg13g2_decap_8
Xclkbuf_5_14__f_clk_regs _556_/CLK clkbuf_4_7_0_clk_regs/X VPWR VGND sg13g2_buf_16
XFILLER_3_611 VPWR VGND sg13g2_decap_8
XFILLER_8_917 VPWR VGND sg13g2_decap_8
XFILLER_3_688 VPWR VGND sg13g2_decap_8
XFILLER_46_331 VPWR VGND sg13g2_decap_8
XFILLER_47_898 VPWR VGND sg13g2_fill_1
XFILLER_47_887 VPWR VGND sg13g2_decap_8
XFILLER_15_773 VPWR VGND sg13g2_decap_8
XFILLER_30_798 VPWR VGND sg13g2_decap_8
X_329_ _494_/D _493_/Q _494_/Q _392_/S VPWR VGND sg13g2_mux2_1
XFILLER_7_972 VPWR VGND sg13g2_decap_8
XFILLER_21_798 VPWR VGND sg13g2_decap_8
XFILLER_0_636 VPWR VGND sg13g2_decap_8
XFILLER_44_846 VPWR VGND sg13g2_decap_4
XFILLER_48_629 VPWR VGND sg13g2_decap_8
XFILLER_12_798 VPWR VGND sg13g2_decap_8
XFILLER_43_378 VPWR VGND sg13g2_decap_8
XFILLER_7_246 VPWR VGND sg13g2_decap_4
XFILLER_4_953 VPWR VGND sg13g2_decap_8
XFILLER_47_651 VPWR VGND sg13g2_decap_8
XFILLER_41_827 VPWR VGND sg13g2_decap_8
XFILLER_1_901 VPWR VGND sg13g2_decap_8
XFILLER_0_433 VPWR VGND sg13g2_decap_8
XFILLER_1_978 VPWR VGND sg13g2_decap_8
XFILLER_48_448 VPWR VGND sg13g2_decap_8
XFILLER_44_643 VPWR VGND sg13g2_decap_8
X_594_ _594_/Q _609_/CLK _594_/D fanout71/X VPWR VGND sg13g2_dfrbpq_1
XFILLER_4_750 VPWR VGND sg13g2_decap_8
XFILLER_23_827 VPWR VGND sg13g2_decap_8
Xdelaybuf_10_clk delaybuf_11_clk/A delaybuf_10_clk/A VPWR VGND sg13g2_buf_16
XFILLER_14_805 VPWR VGND sg13g2_decap_8
XFILLER_41_624 VPWR VGND sg13g2_decap_8
Xoutput31 uo_out[1] _283_/Y VPWR VGND sg13g2_buf_1
Xoutput20 uio_oe[6] _255_/X VPWR VGND sg13g2_buf_1
XFILLER_5_569 VPWR VGND sg13g2_decap_8
XFILLER_1_775 VPWR VGND sg13g2_decap_8
Xclkbuf_2_0__f_clk_delayed _460_/A clkbuf_0_clk_delayed/X VPWR VGND sg13g2_buf_16
XFILLER_49_735 VPWR VGND sg13g2_decap_8
X_577_ _577_/Q _577_/CLK _577_/D fanout83/X VPWR VGND sg13g2_dfrbpq_1
X_646_ _646_/Q _460_/Y _647_/D fanout76/X VPWR VGND sg13g2_dfrbpq_1
XFILLER_13_882 VPWR VGND sg13g2_decap_8
XFILLER_9_875 VPWR VGND sg13g2_decap_8
XFILLER_11_0 VPWR VGND sg13g2_fill_1
XFILLER_48_790 VPWR VGND sg13g2_decap_8
XFILLER_11_819 VPWR VGND sg13g2_decap_8
X_500_ _500_/Q _515_/CLK _500_/D fanout88/X VPWR VGND sg13g2_dfrbpq_1
XFILLER_46_716 VPWR VGND sg13g2_decap_8
X_431_ _596_/D _624_/D _625_/D _436_/S VPWR VGND sg13g2_mux2_1
X_362_ _527_/D _526_/Q _527_/Q _375_/S VPWR VGND sg13g2_mux2_1
XFILLER_10_896 VPWR VGND sg13g2_decap_8
X_293_ _295_/A _470_/Q _473_/Q _474_/Q VPWR VGND sg13g2_nand3b_1
XFILLER_6_856 VPWR VGND sg13g2_decap_8
XFILLER_5_322 VPWR VGND sg13g2_fill_2
XFILLER_1_572 VPWR VGND sg13g2_decap_8
XFILLER_49_532 VPWR VGND sg13g2_decap_8
XFILLER_37_749 VPWR VGND sg13g2_decap_8
X_629_ _629_/Q _629_/CLK _629_/D fanout67/X VPWR VGND sg13g2_dfrbpq_1
XFILLER_44_270 VPWR VGND sg13g2_decap_8
Xclkbuf_5_13__f_clk_regs _567_/CLK clkbuf_4_6_0_clk_regs/X VPWR VGND sg13g2_buf_16
XFILLER_2_325 VPWR VGND sg13g2_decap_4
XFILLER_46_557 VPWR VGND sg13g2_decap_8
XFILLER_41_295 VPWR VGND sg13g2_fill_2
XFILLER_42_730 VPWR VGND sg13g2_decap_8
X_414_ _579_/D _578_/Q _579_/Q _427_/S VPWR VGND sg13g2_mux2_1
X_345_ _510_/D _509_/Q _510_/Q _427_/S VPWR VGND sg13g2_mux2_1
X_276_ _632_/D _610_/Q _624_/Q _278_/S VPWR VGND sg13g2_mux2_1
XFILLER_6_653 VPWR VGND sg13g2_decap_8
XFILLER_0_818 VPWR VGND sg13g2_decap_8
XFILLER_12_903 VPWR VGND sg13g2_decap_8
XFILLER_24_763 VPWR VGND sg13g2_decap_8
XFILLER_3_667 VPWR VGND sg13g2_decap_8
XFILLER_47_833 VPWR VGND sg13g2_decap_8
XFILLER_15_752 VPWR VGND sg13g2_decap_8
XFILLER_46_310 VPWR VGND sg13g2_decap_8
XFILLER_46_387 VPWR VGND sg13g2_decap_8
XFILLER_11_980 VPWR VGND sg13g2_decap_8
XFILLER_30_777 VPWR VGND sg13g2_decap_8
X_328_ _493_/D _492_/Q _493_/Q _332_/S VPWR VGND sg13g2_mux2_1
X_259_ _259_/X _259_/A _259_/B VPWR VGND sg13g2_and2_1
XFILLER_7_951 VPWR VGND sg13g2_decap_8
XFILLER_38_833 VPWR VGND sg13g2_decap_8
XFILLER_21_777 VPWR VGND sg13g2_decap_8
XFILLER_0_615 VPWR VGND sg13g2_decap_8
XFILLER_48_608 VPWR VGND sg13g2_decap_8
XFILLER_44_825 VPWR VGND sg13g2_decap_8
XFILLER_12_777 VPWR VGND sg13g2_decap_8
XFILLER_15_1019 VPWR VGND sg13g2_decap_8
XFILLER_3_420 VPWR VGND sg13g2_decap_4
XFILLER_3_464 VPWR VGND sg13g2_fill_1
XFILLER_7_258 VPWR VGND sg13g2_fill_1
XFILLER_4_932 VPWR VGND sg13g2_decap_8
XFILLER_47_630 VPWR VGND sg13g2_decap_8
XFILLER_26_847 VPWR VGND sg13g2_decap_4
XFILLER_41_806 VPWR VGND sg13g2_decap_8
XFILLER_0_489 VPWR VGND sg13g2_decap_8
XFILLER_1_957 VPWR VGND sg13g2_decap_8
XFILLER_49_939 VPWR VGND sg13g2_decap_8
XFILLER_49_928 VPWR VGND sg13g2_fill_1
XFILLER_49_917 VPWR VGND sg13g2_decap_8
XFILLER_48_427 VPWR VGND sg13g2_decap_8
XFILLER_32_806 VPWR VGND sg13g2_decap_8
XFILLER_44_622 VPWR VGND sg13g2_decap_8
XFILLER_44_699 VPWR VGND sg13g2_decap_8
X_593_ _622_/D _606_/CLK _593_/D fanout74/X VPWR VGND sg13g2_dfrbpq_1
XFILLER_3_250 VPWR VGND sg13g2_fill_1
XFILLER_6_1028 VPWR VGND sg13g2_fill_1
XFILLER_6_1017 VPWR VGND sg13g2_decap_8
XFILLER_23_806 VPWR VGND sg13g2_decap_8
XFILLER_48_961 VPWR VGND sg13g2_fill_2
XFILLER_31_850 VPWR VGND sg13g2_fill_2
XFILLER_41_603 VPWR VGND sg13g2_decap_8
XFILLER_1_754 VPWR VGND sg13g2_decap_8
Xdelaybuf_3_clk delaybuf_4_clk/A _256_/B VPWR VGND sg13g2_buf_16
Xoutput32 uo_out[2] _285_/Y VPWR VGND sg13g2_buf_1
Xoutput21 uio_oe[7] _258_/Y VPWR VGND sg13g2_buf_1
XFILLER_5_548 VPWR VGND sg13g2_decap_8
XFILLER_49_714 VPWR VGND sg13g2_decap_8
X_645_ _645_/Q _459_/Y _645_/D fanout77/X VPWR VGND sg13g2_dfrbpq_1
XFILLER_48_224 VPWR VGND sg13g2_fill_2
XFILLER_13_861 VPWR VGND sg13g2_decap_8
XFILLER_20_809 VPWR VGND sg13g2_decap_8
X_576_ _576_/Q _576_/CLK _576_/D fanout82/X VPWR VGND sg13g2_dfrbpq_1
XFILLER_9_854 VPWR VGND sg13g2_decap_8
Xclkbuf_5_12__f_clk_regs _570_/CLK clkbuf_4_6_0_clk_regs/X VPWR VGND sg13g2_buf_16
XFILLER_11_1022 VPWR VGND sg13g2_decap_8
XFILLER_39_791 VPWR VGND sg13g2_decap_8
X_430_ _595_/D _594_/Q _624_/D _436_/S VPWR VGND sg13g2_mux2_1
X_361_ _526_/D _525_/Q _526_/Q _375_/S VPWR VGND sg13g2_mux2_1
X_292_ _307_/A _473_/Q _474_/Q VPWR VGND sg13g2_and2_1
XFILLER_10_875 VPWR VGND sg13g2_decap_8
XFILLER_6_835 VPWR VGND sg13g2_decap_8
XFILLER_1_551 VPWR VGND sg13g2_decap_8
XFILLER_49_511 VPWR VGND sg13g2_decap_8
X_628_ _628_/Q _629_/CLK _628_/D fanout66/X VPWR VGND sg13g2_dfrbpq_1
XFILLER_49_588 VPWR VGND sg13g2_decap_8
X_559_ _559_/Q _562_/CLK _559_/D fanout93/X VPWR VGND sg13g2_dfrbpq_1
XFILLER_36_794 VPWR VGND sg13g2_decap_8
XFILLER_3_849 VPWR VGND sg13g2_decap_8
XFILLER_15_901 VPWR VGND sg13g2_fill_1
X_413_ _578_/D _577_/Q _578_/Q _429_/S VPWR VGND sg13g2_mux2_1
XFILLER_15_956 VPWR VGND sg13g2_fill_2
XFILLER_42_786 VPWR VGND sg13g2_decap_8
X_344_ _509_/D _508_/Q _509_/Q _427_/S VPWR VGND sg13g2_mux2_1
X_275_ _631_/D _609_/Q _623_/Q _275_/S VPWR VGND sg13g2_mux2_1
XFILLER_6_632 VPWR VGND sg13g2_decap_8
XFILLER_49_385 VPWR VGND sg13g2_decap_8
XFILLER_12_959 VPWR VGND sg13g2_decap_8
XFILLER_7_429 VPWR VGND sg13g2_decap_8
XFILLER_3_646 VPWR VGND sg13g2_decap_8
XFILLER_47_812 VPWR VGND sg13g2_decap_8
XFILLER_42_583 VPWR VGND sg13g2_decap_8
XFILLER_46_366 VPWR VGND sg13g2_decap_8
XFILLER_30_756 VPWR VGND sg13g2_decap_8
X_327_ _492_/D _491_/Q _492_/Q _332_/S VPWR VGND sg13g2_mux2_1
X_258_ _258_/Y _258_/A _258_/B VPWR VGND sg13g2_nor2_1
XFILLER_7_930 VPWR VGND sg13g2_decap_8
XFILLER_9_1015 VPWR VGND sg13g2_decap_8
XFILLER_6_495 VPWR VGND sg13g2_fill_2
XFILLER_38_812 VPWR VGND sg13g2_decap_8
Xclkbuf_4_9_0_clk_regs clkbuf_4_9_0_clk_regs/X clkbuf_0_clk_regs/X VPWR VGND sg13g2_buf_8
XFILLER_21_756 VPWR VGND sg13g2_decap_8
XFILLER_47_1021 VPWR VGND sg13g2_decap_8
XFILLER_29_812 VPWR VGND sg13g2_decap_8
XFILLER_29_823 VPWR VGND sg13g2_fill_2
XFILLER_44_804 VPWR VGND sg13g2_decap_8
XFILLER_12_756 VPWR VGND sg13g2_decap_8
XFILLER_8_749 VPWR VGND sg13g2_decap_8
XFILLER_4_911 VPWR VGND sg13g2_decap_8
XFILLER_1_0 VPWR VGND sg13g2_fill_1
XFILLER_4_988 VPWR VGND sg13g2_decap_8
XFILLER_35_837 VPWR VGND sg13g2_decap_8
XFILLER_47_686 VPWR VGND sg13g2_decap_8
XFILLER_34_0 VPWR VGND sg13g2_fill_2
XFILLER_26_826 VPWR VGND sg13g2_decap_8
XFILLER_1_936 VPWR VGND sg13g2_decap_8
XFILLER_0_468 VPWR VGND sg13g2_decap_8
XFILLER_17_826 VPWR VGND sg13g2_decap_8
XFILLER_44_601 VPWR VGND sg13g2_decap_8
X_592_ _592_/Q _621_/CLK _592_/D fanout85/X VPWR VGND sg13g2_dfrbpq_1
XFILLER_48_406 VPWR VGND sg13g2_decap_8
XFILLER_40_851 VPWR VGND sg13g2_fill_1
XFILLER_44_678 VPWR VGND sg13g2_decap_8
Xclkbuf_5_11__f_clk_regs _571_/CLK clkbuf_4_5_0_clk_regs/X VPWR VGND sg13g2_buf_16
XFILLER_4_785 VPWR VGND sg13g2_decap_8
XFILLER_47_483 VPWR VGND sg13g2_decap_4
XFILLER_16_881 VPWR VGND sg13g2_fill_1
XFILLER_22_851 VPWR VGND sg13g2_fill_1
XFILLER_41_659 VPWR VGND sg13g2_decap_8
XFILLER_5_527 VPWR VGND sg13g2_decap_8
XFILLER_0_265 VPWR VGND sg13g2_fill_1
XFILLER_1_733 VPWR VGND sg13g2_decap_8
Xoutput33 uo_out[3] _287_/Y VPWR VGND sg13g2_buf_1
Xoutput22 uio_out[0] _242_/X VPWR VGND sg13g2_buf_1
X_575_ _575_/Q _576_/CLK _575_/D fanout82/X VPWR VGND sg13g2_dfrbpq_1
X_644_ _644_/Q _458_/Y _644_/D fanout76/X VPWR VGND sg13g2_dfrbpq_1
XFILLER_13_840 VPWR VGND sg13g2_decap_8
XFILLER_9_833 VPWR VGND sg13g2_decap_8
XFILLER_4_582 VPWR VGND sg13g2_decap_8
XFILLER_47_280 VPWR VGND sg13g2_decap_8
XFILLER_11_1001 VPWR VGND sg13g2_decap_8
XFILLER_2_519 VPWR VGND sg13g2_decap_8
XFILLER_39_770 VPWR VGND sg13g2_decap_8
XFILLER_10_854 VPWR VGND sg13g2_decap_8
XFILLER_41_401 VPWR VGND sg13g2_fill_1
X_360_ _525_/D _524_/Q _525_/Q _375_/S VPWR VGND sg13g2_mux2_1
X_291_ _291_/Y _602_/Q _291_/B VPWR VGND sg13g2_nand2b_1
Xclkbuf_4_11_0_clk_regs clkbuf_4_11_0_clk_regs/X clkbuf_0_clk_regs/X VPWR VGND sg13g2_buf_8
XFILLER_6_814 VPWR VGND sg13g2_decap_8
XFILLER_5_324 VPWR VGND sg13g2_fill_1
XFILLER_1_530 VPWR VGND sg13g2_decap_8
XFILLER_49_567 VPWR VGND sg13g2_decap_8
XFILLER_45_784 VPWR VGND sg13g2_decap_8
X_558_ _558_/Q _562_/CLK _558_/D fanout93/X VPWR VGND sg13g2_dfrbpq_1
X_627_ _627_/Q _630_/CLK _627_/D fanout64/X VPWR VGND sg13g2_dfrbpq_1
X_489_ _489_/Q _513_/CLK _489_/D fanout87/X VPWR VGND sg13g2_dfrbpq_1
XFILLER_5_891 VPWR VGND sg13g2_decap_8
XFILLER_36_784 VPWR VGND sg13g2_fill_2
XFILLER_3_828 VPWR VGND sg13g2_decap_8
XFILLER_5_7 VPWR VGND sg13g2_fill_1
XFILLER_2_349 VPWR VGND sg13g2_fill_2
XFILLER_27_784 VPWR VGND sg13g2_decap_8
XFILLER_42_765 VPWR VGND sg13g2_decap_8
X_412_ _577_/D _576_/Q _577_/Q _412_/S VPWR VGND sg13g2_mux2_1
X_343_ _508_/D _507_/Q _508_/Q _429_/S VPWR VGND sg13g2_mux2_1
X_274_ _638_/D _616_/Q _630_/Q _278_/S VPWR VGND sg13g2_mux2_1
XFILLER_6_611 VPWR VGND sg13g2_decap_8
XFILLER_2_883 VPWR VGND sg13g2_decap_8
XFILLER_6_688 VPWR VGND sg13g2_decap_8
XFILLER_5_198 VPWR VGND sg13g2_decap_8
XFILLER_49_364 VPWR VGND sg13g2_decap_8
XFILLER_18_784 VPWR VGND sg13g2_decap_8
XFILLER_33_776 VPWR VGND sg13g2_decap_8
XFILLER_33_787 VPWR VGND sg13g2_fill_1
XFILLER_45_581 VPWR VGND sg13g2_decap_8
XFILLER_12_938 VPWR VGND sg13g2_decap_8
XFILLER_24_798 VPWR VGND sg13g2_decap_8
XFILLER_2_168 VPWR VGND sg13g2_fill_2
XFILLER_3_625 VPWR VGND sg13g2_decap_8
XFILLER_46_345 VPWR VGND sg13g2_decap_8
XFILLER_48_53 VPWR VGND sg13g2_fill_2
XFILLER_15_787 VPWR VGND sg13g2_decap_8
XFILLER_42_562 VPWR VGND sg13g2_decap_8
X_326_ _491_/D _490_/Q _491_/Q _332_/S VPWR VGND sg13g2_mux2_1
Xfanout90 fanout90/X fanout92/X VPWR VGND sg13g2_buf_1
XFILLER_7_986 VPWR VGND sg13g2_decap_8
XFILLER_2_680 VPWR VGND sg13g2_decap_8
XFILLER_47_1000 VPWR VGND sg13g2_decap_8
XFILLER_18_34 VPWR VGND sg13g2_fill_2
XFILLER_7_227 VPWR VGND sg13g2_fill_2
XFILLER_7_216 VPWR VGND sg13g2_decap_8
XFILLER_3_499 VPWR VGND sg13g2_decap_8
Xclkbuf_5_10__f_clk_regs _576_/CLK clkbuf_4_5_0_clk_regs/X VPWR VGND sg13g2_buf_16
XFILLER_4_967 VPWR VGND sg13g2_decap_8
XFILLER_35_816 VPWR VGND sg13g2_decap_8
XFILLER_47_665 VPWR VGND sg13g2_decap_8
X_309_ _474_/D _307_/A _307_/B _308_/Y VPWR VGND sg13g2_a21oi_1
XFILLER_7_783 VPWR VGND sg13g2_decap_8
XFILLER_6_293 VPWR VGND sg13g2_decap_4
XFILLER_26_805 VPWR VGND sg13g2_decap_8
Xclkbuf_5_29__f_clk_regs _563_/CLK clkbuf_4_14_0_clk_regs/X VPWR VGND sg13g2_buf_16
Xdelaybuf_22_clk delaybuf_22_clk/X delaybuf_22_clk/A VPWR VGND sg13g2_buf_16
XFILLER_14_1010 VPWR VGND sg13g2_decap_8
XFILLER_5_709 VPWR VGND sg13g2_decap_8
XFILLER_0_447 VPWR VGND sg13g2_decap_8
XFILLER_1_915 VPWR VGND sg13g2_decap_8
Xdelaybuf_13_clk delaybuf_14_clk/A delaybuf_13_clk/A VPWR VGND sg13g2_buf_16
XFILLER_17_805 VPWR VGND sg13g2_decap_8
XFILLER_44_657 VPWR VGND sg13g2_decap_8
X_591_ _591_/Q _622_/CLK _591_/D fanout73/X VPWR VGND sg13g2_dfrbpq_1
X_660_ _660_/Q _660_/CLK _660_/D fanout78/X VPWR VGND sg13g2_dfrbpq_1
XFILLER_40_830 VPWR VGND sg13g2_decap_8
XFILLER_6_59 VPWR VGND sg13g2_fill_2
XFILLER_4_764 VPWR VGND sg13g2_decap_8
XFILLER_16_860 VPWR VGND sg13g2_fill_1
XFILLER_47_462 VPWR VGND sg13g2_decap_8
XFILLER_7_580 VPWR VGND sg13g2_decap_8
XFILLER_14_819 VPWR VGND sg13g2_decap_8
XFILLER_22_830 VPWR VGND sg13g2_decap_8
XFILLER_41_638 VPWR VGND sg13g2_decap_8
Xoutput34 uo_out[4] _289_/Y VPWR VGND sg13g2_buf_1
Xoutput23 uio_out[1] _243_/X VPWR VGND sg13g2_buf_1
XFILLER_0_200 VPWR VGND sg13g2_decap_8
XFILLER_0_244 VPWR VGND sg13g2_fill_1
XFILLER_1_712 VPWR VGND sg13g2_decap_8
XFILLER_1_789 VPWR VGND sg13g2_decap_8
XFILLER_49_749 VPWR VGND sg13g2_decap_8
XFILLER_48_259 VPWR VGND sg13g2_decap_8
X_574_ _574_/Q _576_/CLK _574_/D fanout82/X VPWR VGND sg13g2_dfrbpq_1
X_643_ _643_/Q _457_/Y _643_/D fanout76/X VPWR VGND sg13g2_dfrbpq_1
XFILLER_13_896 VPWR VGND sg13g2_decap_8
XFILLER_9_889 VPWR VGND sg13g2_decap_8
XFILLER_9_812 VPWR VGND sg13g2_decap_8
XFILLER_4_561 VPWR VGND sg13g2_decap_8
XFILLER_10_833 VPWR VGND sg13g2_decap_8
X_290_ _311_/S _602_/Q _291_/B VPWR VGND sg13g2_nor2b_1
XFILLER_1_586 VPWR VGND sg13g2_decap_8
XFILLER_49_546 VPWR VGND sg13g2_decap_8
XFILLER_44_284 VPWR VGND sg13g2_decap_8
XFILLER_45_763 VPWR VGND sg13g2_decap_8
X_557_ _557_/Q _557_/CLK _557_/D fanout97/X VPWR VGND sg13g2_dfrbpq_1
X_626_ _626_/Q _626_/CLK _626_/D fanout69/X VPWR VGND sg13g2_dfrbpq_1
X_488_ _488_/Q _570_/CLK _488_/D fanout91/X VPWR VGND sg13g2_dfrbpq_1
XFILLER_5_870 VPWR VGND sg13g2_decap_8
XFILLER_36_763 VPWR VGND sg13g2_decap_8
XFILLER_2_306 VPWR VGND sg13g2_fill_2
XFILLER_3_807 VPWR VGND sg13g2_decap_8
XFILLER_27_763 VPWR VGND sg13g2_decap_8
XFILLER_42_744 VPWR VGND sg13g2_decap_8
X_411_ _576_/D _575_/Q _576_/Q _411_/S VPWR VGND sg13g2_mux2_1
X_342_ _507_/D _506_/Q _507_/Q _429_/S VPWR VGND sg13g2_mux2_1
XFILLER_41_276 VPWR VGND sg13g2_fill_2
X_273_ _637_/D _615_/Q _629_/Q _278_/S VPWR VGND sg13g2_mux2_1
XFILLER_6_667 VPWR VGND sg13g2_decap_8
XFILLER_2_862 VPWR VGND sg13g2_decap_8
XFILLER_18_763 VPWR VGND sg13g2_decap_8
XFILLER_45_560 VPWR VGND sg13g2_decap_8
X_609_ _609_/Q _609_/CLK _609_/D fanout71/X VPWR VGND sg13g2_dfrbpq_1
XFILLER_49_343 VPWR VGND sg13g2_decap_8
XFILLER_12_917 VPWR VGND sg13g2_decap_8
XFILLER_24_777 VPWR VGND sg13g2_decap_8
XFILLER_3_604 VPWR VGND sg13g2_decap_8
XFILLER_46_324 VPWR VGND sg13g2_decap_8
XFILLER_47_847 VPWR VGND sg13g2_fill_2
XFILLER_15_766 VPWR VGND sg13g2_decap_8
Xfanout91 fanout91/X fanout92/X VPWR VGND sg13g2_buf_1
Xfanout80 fanout80/X fanout81/X VPWR VGND sg13g2_buf_1
X_325_ _490_/D _489_/Q _490_/Q _332_/S VPWR VGND sg13g2_mux2_1
XFILLER_11_994 VPWR VGND sg13g2_decap_8
X_256_ _256_/Y _441_/A _256_/B VPWR VGND sg13g2_xnor2_1
XFILLER_7_965 VPWR VGND sg13g2_decap_8
XFILLER_38_847 VPWR VGND sg13g2_decap_4
Xclkbuf_5_28__f_clk_regs _562_/CLK clkbuf_4_14_0_clk_regs/X VPWR VGND sg13g2_buf_16
Xclkbuf_leaf_1_clk _460_/B delaybuf_16_clk/X VPWR VGND sg13g2_buf_8
XFILLER_0_629 VPWR VGND sg13g2_decap_8
XFILLER_44_839 VPWR VGND sg13g2_decap_8
Xu_delay_line VPWR VGND u_delay_line/clk clkbuf_0_clk_delayed/A fanout94/X _566_/Q
+ _567_/Q _568_/Q _569_/Q _542_/Q _552_/Q _553_/Q _554_/Q _555_/Q _556_/Q _557_/Q
+ _558_/Q _559_/Q _560_/Q _561_/Q _543_/Q _562_/Q _563_/Q _564_/Q _565_/Q _544_/Q
+ _545_/Q _546_/Q _547_/Q _548_/Q _549_/Q _550_/Q _551_/Q delay_line
Xclkload0 clkload0/X clkload0/A VPWR VGND sg13g2_buf_8
XFILLER_7_239 VPWR VGND sg13g2_decap_8
XFILLER_4_946 VPWR VGND sg13g2_decap_8
XFILLER_47_644 VPWR VGND sg13g2_decap_8
XFILLER_11_791 VPWR VGND sg13g2_decap_8
X_308_ _308_/Y _473_/Q _307_/B _474_/Q VPWR VGND sg13g2_a21oi_1
X_239_ _239_/X _654_/Q _247_/B VPWR VGND sg13g2_and2_1
XFILLER_7_762 VPWR VGND sg13g2_decap_8
XFILLER_0_426 VPWR VGND sg13g2_decap_8
XFILLER_44_636 VPWR VGND sg13g2_decap_8
XFILLER_45_99 VPWR VGND sg13g2_fill_1
X_590_ _590_/Q _622_/CLK _590_/D fanout73/X VPWR VGND sg13g2_dfrbpq_1
Xdelaybuf_6_clk delaybuf_7_clk/A delaybuf_6_clk/A VPWR VGND sg13g2_buf_16
XFILLER_4_743 VPWR VGND sg13g2_decap_8
XFILLER_0_993 VPWR VGND sg13g2_decap_8
XFILLER_47_441 VPWR VGND sg13g2_decap_8
XFILLER_41_617 VPWR VGND sg13g2_decap_8
Xoutput35 uo_out[5] _239_/X VPWR VGND sg13g2_buf_1
Xoutput24 uio_out[2] _244_/X VPWR VGND sg13g2_buf_1
XFILLER_1_768 VPWR VGND sg13g2_decap_8
X_642_ _642_/Q _456_/Y _642_/D fanout73/X VPWR VGND sg13g2_dfrbpq_1
XFILLER_49_728 VPWR VGND sg13g2_decap_8
XFILLER_44_422 VPWR VGND sg13g2_decap_8
X_573_ _573_/Q _576_/CLK _573_/D fanout82/X VPWR VGND sg13g2_dfrbpq_1
XFILLER_13_875 VPWR VGND sg13g2_decap_8
XFILLER_9_868 VPWR VGND sg13g2_decap_8
XFILLER_4_540 VPWR VGND sg13g2_decap_8
XFILLER_0_790 VPWR VGND sg13g2_decap_8
XFILLER_48_783 VPWR VGND sg13g2_decap_8
XFILLER_46_709 VPWR VGND sg13g2_decap_8
XFILLER_10_812 VPWR VGND sg13g2_decap_8
XFILLER_10_889 VPWR VGND sg13g2_decap_8
XFILLER_6_849 VPWR VGND sg13g2_decap_8
XFILLER_5_315 VPWR VGND sg13g2_decap_8
XFILLER_1_565 VPWR VGND sg13g2_decap_8
XFILLER_45_742 VPWR VGND sg13g2_decap_8
X_625_ _625_/Q _626_/CLK _625_/D fanout65/X VPWR VGND sg13g2_dfrbpq_1
XFILLER_49_525 VPWR VGND sg13g2_decap_8
X_556_ _556_/Q _556_/CLK _556_/D fanout96/X VPWR VGND sg13g2_dfrbpq_1
X_487_ _487_/Q _570_/CLK _487_/D fanout92/X VPWR VGND sg13g2_dfrbpq_1
XFILLER_48_580 VPWR VGND sg13g2_decap_8
XFILLER_12_37 VPWR VGND sg13g2_fill_1
XFILLER_2_318 VPWR VGND sg13g2_decap_8
Xhold120 _620_/D _591_/Q VPWR VGND sg13g2_dlygate4sd3_1
XFILLER_2_1023 VPWR VGND sg13g2_decap_4
XFILLER_41_288 VPWR VGND sg13g2_decap_8
XFILLER_42_723 VPWR VGND sg13g2_decap_8
X_410_ _575_/D _574_/Q _575_/Q _411_/S VPWR VGND sg13g2_mux2_1
X_341_ _506_/D _505_/Q _506_/Q _427_/S VPWR VGND sg13g2_mux2_1
X_272_ _636_/D _614_/Q _628_/Q _278_/S VPWR VGND sg13g2_mux2_1
XFILLER_6_646 VPWR VGND sg13g2_decap_8
XFILLER_2_841 VPWR VGND sg13g2_decap_8
Xclkbuf_5_27__f_clk_regs _498_/CLK clkbuf_4_13_0_clk_regs/X VPWR VGND sg13g2_buf_16
XFILLER_49_322 VPWR VGND sg13g2_decap_8
X_608_ _608_/Q _629_/CLK _608_/D fanout71/X VPWR VGND sg13g2_dfrbpq_1
XFILLER_49_399 VPWR VGND sg13g2_decap_8
X_539_ _539_/Q _611_/CLK _539_/D fanout69/X VPWR VGND sg13g2_dfrbpq_1
XFILLER_24_756 VPWR VGND sg13g2_decap_8
XFILLER_46_303 VPWR VGND sg13g2_decap_8
XFILLER_47_826 VPWR VGND sg13g2_decap_8
XFILLER_11_973 VPWR VGND sg13g2_decap_8
XFILLER_42_597 VPWR VGND sg13g2_decap_8
Xfanout70 fanout70/X fanout75/X VPWR VGND sg13g2_buf_1
Xfanout92 fanout92/X input1/X VPWR VGND sg13g2_buf_1
Xfanout81 fanout81/X fanout84/X VPWR VGND sg13g2_buf_1
X_324_ _489_/D _488_/Q _489_/Q _427_/S VPWR VGND sg13g2_mux2_1
X_255_ _255_/X _645_/Q _255_/B VPWR VGND sg13g2_and2_1
XFILLER_9_27 VPWR VGND sg13g2_fill_1
XFILLER_7_944 VPWR VGND sg13g2_decap_8
XFILLER_6_454 VPWR VGND sg13g2_decap_4
XFILLER_38_826 VPWR VGND sg13g2_decap_8
XFILLER_0_608 VPWR VGND sg13g2_decap_8
XFILLER_43_306 VPWR VGND sg13g2_fill_2
XFILLER_44_818 VPWR VGND sg13g2_decap_8
Xclkload1 clkload1/Y _449_/B VPWR VGND sg13g2_inv_4
XFILLER_20_781 VPWR VGND sg13g2_decap_8
XFILLER_3_413 VPWR VGND sg13g2_decap_8
XFILLER_3_424 VPWR VGND sg13g2_fill_1
XFILLER_4_925 VPWR VGND sg13g2_decap_8
XFILLER_47_623 VPWR VGND sg13g2_decap_8
XFILLER_43_840 VPWR VGND sg13g2_decap_8
XFILLER_43_851 VPWR VGND sg13g2_fill_1
XFILLER_11_770 VPWR VGND sg13g2_decap_8
X_307_ _310_/B _307_/A _307_/B VPWR VGND sg13g2_nand2_1
X_238_ _258_/A _255_/B VPWR VGND sg13g2_inv_1
XFILLER_7_741 VPWR VGND sg13g2_decap_8
XFILLER_25_840 VPWR VGND sg13g2_decap_8
XFILLER_25_851 VPWR VGND sg13g2_fill_1
XFILLER_44_615 VPWR VGND sg13g2_decap_8
Xclkbuf_4_8_0_clk_regs clkbuf_4_8_0_clk_regs/X clkbuf_0_clk_regs/X VPWR VGND sg13g2_buf_8
XFILLER_4_799 VPWR VGND sg13g2_decap_8
XFILLER_4_722 VPWR VGND sg13g2_decap_8
XFILLER_0_972 VPWR VGND sg13g2_decap_8
XFILLER_47_420 VPWR VGND sg13g2_decap_8
XFILLER_16_851 VPWR VGND sg13g2_decap_8
XFILLER_43_681 VPWR VGND sg13g2_decap_8
XFILLER_1_747 VPWR VGND sg13g2_decap_8
Xoutput36 uo_out[6] _240_/X VPWR VGND sg13g2_buf_1
Xoutput25 uio_out[3] _245_/X VPWR VGND sg13g2_buf_1
Xoutput14 uio_oe[0] _249_/X VPWR VGND sg13g2_buf_1
XFILLER_49_707 VPWR VGND sg13g2_decap_8
XFILLER_44_401 VPWR VGND sg13g2_decap_8
X_572_ _572_/Q _577_/CLK _572_/D fanout82/X VPWR VGND sg13g2_dfrbpq_1
X_641_ _641_/Q _455_/Y _641_/D fanout86/X VPWR VGND sg13g2_dfrbpq_1
XFILLER_5_1010 VPWR VGND sg13g2_decap_8
XFILLER_13_854 VPWR VGND sg13g2_decap_8
XFILLER_9_847 VPWR VGND sg13g2_decap_8
XFILLER_4_596 VPWR VGND sg13g2_decap_8
XFILLER_48_762 VPWR VGND sg13g2_decap_8
XFILLER_47_294 VPWR VGND sg13g2_decap_8
XFILLER_47_250 VPWR VGND sg13g2_decap_4
XFILLER_11_1015 VPWR VGND sg13g2_decap_8
XFILLER_39_784 VPWR VGND sg13g2_decap_8
XFILLER_10_868 VPWR VGND sg13g2_decap_8
XFILLER_6_828 VPWR VGND sg13g2_decap_8
XFILLER_1_544 VPWR VGND sg13g2_decap_8
Xclkbuf_5_26__f_clk_regs _515_/CLK clkbuf_4_13_0_clk_regs/X VPWR VGND sg13g2_buf_16
XFILLER_49_504 VPWR VGND sg13g2_decap_8
XFILLER_45_721 VPWR VGND sg13g2_decap_8
XFILLER_45_798 VPWR VGND sg13g2_decap_8
X_555_ _555_/Q _557_/CLK _555_/D fanout96/X VPWR VGND sg13g2_dfrbpq_1
X_624_ _624_/Q _626_/CLK _624_/D fanout66/X VPWR VGND sg13g2_dfrbpq_1
X_486_ _486_/Q _486_/CLK _486_/D fanout92/X VPWR VGND sg13g2_dfrbpq_1
Xhold110 _660_/D _464_/Q VPWR VGND sg13g2_dlygate4sd3_1
Xhold121 _628_/D _599_/Q VPWR VGND sg13g2_dlygate4sd3_1
XFILLER_2_1002 VPWR VGND sg13g2_decap_8
XFILLER_37_46 VPWR VGND sg13g2_fill_2
XFILLER_42_702 VPWR VGND sg13g2_decap_8
XFILLER_27_798 VPWR VGND sg13g2_decap_8
XFILLER_42_779 VPWR VGND sg13g2_decap_8
X_340_ _505_/D _504_/Q _505_/Q _416_/S VPWR VGND sg13g2_mux2_1
X_271_ _635_/D _613_/Q _627_/Q _278_/S VPWR VGND sg13g2_mux2_1
XFILLER_2_820 VPWR VGND sg13g2_decap_8
XFILLER_6_625 VPWR VGND sg13g2_decap_8
XFILLER_2_897 VPWR VGND sg13g2_decap_8
XFILLER_49_378 VPWR VGND sg13g2_decap_8
XFILLER_49_301 VPWR VGND sg13g2_decap_8
XFILLER_18_798 VPWR VGND sg13g2_decap_8
XFILLER_45_595 VPWR VGND sg13g2_decap_8
X_538_ _538_/Q _626_/CLK _538_/D fanout69/X VPWR VGND sg13g2_dfrbpq_1
X_607_ _607_/Q _621_/CLK _607_/D fanout86/X VPWR VGND sg13g2_dfrbpq_1
XFILLER_14_982 VPWR VGND sg13g2_decap_8
X_469_ _469_/Q _576_/CLK _469_/D fanout80/X VPWR VGND sg13g2_dfrbpq_1
XFILLER_4_190 VPWR VGND sg13g2_fill_1
Xclkbuf_4_10_0_clk_regs clkbuf_4_10_0_clk_regs/X clkbuf_0_clk_regs/X VPWR VGND sg13g2_buf_8
XFILLER_3_639 VPWR VGND sg13g2_decap_8
XFILLER_47_805 VPWR VGND sg13g2_decap_8
XFILLER_46_359 VPWR VGND sg13g2_decap_8
XFILLER_47_849 VPWR VGND sg13g2_fill_1
XFILLER_11_952 VPWR VGND sg13g2_decap_8
XFILLER_30_749 VPWR VGND sg13g2_decap_8
XFILLER_42_576 VPWR VGND sg13g2_decap_8
Xfanout60 fanout60/X _291_/Y VPWR VGND sg13g2_buf_1
Xfanout71 fanout71/X fanout72/X VPWR VGND sg13g2_buf_1
Xfanout93 fanout93/X fanout94/X VPWR VGND sg13g2_buf_1
Xfanout82 fanout82/X fanout84/X VPWR VGND sg13g2_buf_1
X_323_ _488_/D _487_/Q _488_/Q _369_/S VPWR VGND sg13g2_mux2_1
X_254_ _254_/X _643_/Q _255_/B VPWR VGND sg13g2_and2_1
XFILLER_7_923 VPWR VGND sg13g2_decap_8
XFILLER_2_694 VPWR VGND sg13g2_decap_8
XFILLER_9_1008 VPWR VGND sg13g2_decap_8
XFILLER_38_805 VPWR VGND sg13g2_decap_8
XFILLER_21_749 VPWR VGND sg13g2_decap_8
XFILLER_45_392 VPWR VGND sg13g2_decap_8
Xdelaybuf_25_clk delaybuf_26_clk/A delaybuf_25_clk/A VPWR VGND sg13g2_buf_16
XFILLER_29_805 VPWR VGND sg13g2_decap_8
XFILLER_47_1014 VPWR VGND sg13g2_decap_8
XFILLER_12_749 VPWR VGND sg13g2_decap_8
Xclkload2 clkload2/Y _440_/B VPWR VGND sg13g2_inv_4
Xdelaybuf_16_clk delaybuf_16_clk/X delaybuf_16_clk/A VPWR VGND sg13g2_buf_16
XFILLER_4_904 VPWR VGND sg13g2_decap_8
XFILLER_47_679 VPWR VGND sg13g2_decap_8
XFILLER_47_602 VPWR VGND sg13g2_decap_8
X_306_ _473_/D _473_/Q _307_/B VPWR VGND sg13g2_xor2_1
X_237_ _237_/X _281_/A _279_/B VPWR VGND sg13g2_and2_1
XFILLER_7_797 VPWR VGND sg13g2_decap_8
XFILLER_7_720 VPWR VGND sg13g2_decap_8
XFILLER_2_491 VPWR VGND sg13g2_decap_8
XFILLER_26_819 VPWR VGND sg13g2_decap_8
XFILLER_14_1024 VPWR VGND sg13g2_decap_4
XFILLER_1_929 VPWR VGND sg13g2_decap_8
XFILLER_17_819 VPWR VGND sg13g2_decap_8
XFILLER_40_844 VPWR VGND sg13g2_decap_8
XFILLER_4_701 VPWR VGND sg13g2_decap_8
XFILLER_0_951 VPWR VGND sg13g2_decap_8
XFILLER_3_299 VPWR VGND sg13g2_fill_2
XFILLER_4_778 VPWR VGND sg13g2_decap_8
XFILLER_16_830 VPWR VGND sg13g2_decap_8
XFILLER_47_487 VPWR VGND sg13g2_fill_2
XFILLER_47_476 VPWR VGND sg13g2_decap_8
XFILLER_7_594 VPWR VGND sg13g2_decap_8
XFILLER_22_844 VPWR VGND sg13g2_decap_8
Xclkbuf_5_25__f_clk_regs _513_/CLK clkbuf_4_12_0_clk_regs/X VPWR VGND sg13g2_buf_16
XFILLER_1_726 VPWR VGND sg13g2_decap_8
Xoutput37 uo_out[7] _241_/X VPWR VGND sg13g2_buf_1
Xoutput26 uio_out[4] _247_/B VPWR VGND sg13g2_buf_1
Xoutput15 uio_oe[1] _250_/X VPWR VGND sg13g2_buf_1
X_571_ _571_/Q _571_/CLK _571_/D fanout83/X VPWR VGND sg13g2_dfrbpq_1
X_640_ _640_/Q _454_/Y _640_/D fanout90/X VPWR VGND sg13g2_dfrbpq_1
XFILLER_13_833 VPWR VGND sg13g2_decap_8
XFILLER_44_468 VPWR VGND sg13g2_fill_1
XFILLER_9_826 VPWR VGND sg13g2_decap_8
XFILLER_4_575 VPWR VGND sg13g2_decap_8
XFILLER_48_741 VPWR VGND sg13g2_decap_8
Xclkbuf_0_clk_delayed clkbuf_0_clk_delayed/X clkbuf_0_clk_delayed/A VPWR VGND sg13g2_buf_16
XFILLER_39_763 VPWR VGND sg13g2_decap_8
Xclkbuf_5_9__f_clk_regs _577_/CLK clkbuf_4_4_0_clk_regs/X VPWR VGND sg13g2_buf_16
XFILLER_10_847 VPWR VGND sg13g2_decap_8
XFILLER_6_807 VPWR VGND sg13g2_decap_8
XFILLER_1_523 VPWR VGND sg13g2_decap_8
XFILLER_44_210 VPWR VGND sg13g2_fill_2
XFILLER_44_298 VPWR VGND sg13g2_fill_2
XFILLER_45_700 VPWR VGND sg13g2_decap_8
XFILLER_45_777 VPWR VGND sg13g2_decap_8
X_554_ _554_/Q _557_/CLK _554_/D fanout96/X VPWR VGND sg13g2_dfrbpq_1
X_623_ _623_/Q _623_/CLK _623_/D fanout71/X VPWR VGND sg13g2_dfrbpq_1
X_485_ _485_/Q _486_/CLK _485_/D fanout91/X VPWR VGND sg13g2_dfrbpq_1
XFILLER_5_884 VPWR VGND sg13g2_decap_8
XFILLER_4_350 VPWR VGND sg13g2_decap_8
XFILLER_36_777 VPWR VGND sg13g2_decap_8
Xhold122 _613_/D _586_/Q VPWR VGND sg13g2_dlygate4sd3_1
Xhold111 _615_/D _588_/Q VPWR VGND sg13g2_dlygate4sd3_1
Xhold100 _259_/B _644_/Q VPWR VGND sg13g2_dlygate4sd3_1
XFILLER_27_777 VPWR VGND sg13g2_decap_8
XFILLER_42_758 VPWR VGND sg13g2_decap_8
X_270_ _642_/D _608_/Q _622_/Q _275_/S VPWR VGND sg13g2_mux2_1
XFILLER_6_604 VPWR VGND sg13g2_decap_8
XFILLER_2_876 VPWR VGND sg13g2_decap_8
XFILLER_49_357 VPWR VGND sg13g2_decap_8
XFILLER_18_777 VPWR VGND sg13g2_decap_8
XFILLER_33_769 VPWR VGND sg13g2_decap_8
XFILLER_45_574 VPWR VGND sg13g2_decap_8
X_537_ _537_/Q _615_/CLK _537_/D fanout72/X VPWR VGND sg13g2_dfrbpq_1
X_606_ _606_/Q _606_/CLK _606_/D fanout85/X VPWR VGND sg13g2_dfrbpq_1
X_468_ _656_/D _444_/Y _468_/D fanout77/X VPWR VGND sg13g2_dfrbpq_1
X_399_ _564_/D _563_/Q _564_/Q _405_/S VPWR VGND sg13g2_mux2_1
Xclkbuf_leaf_4_clk _456_/B clkload0/A VPWR VGND sg13g2_buf_8
XFILLER_5_681 VPWR VGND sg13g2_decap_8
XFILLER_32_791 VPWR VGND sg13g2_decap_4
XFILLER_3_618 VPWR VGND sg13g2_decap_8
XFILLER_46_338 VPWR VGND sg13g2_decap_8
X_322_ _487_/D _486_/Q _487_/Q _322_/S VPWR VGND sg13g2_mux2_1
XFILLER_11_931 VPWR VGND sg13g2_decap_8
Xfanout50 _416_/S _322_/S VPWR VGND sg13g2_buf_1
Xfanout61 _247_/B _255_/B VPWR VGND sg13g2_buf_1
Xfanout72 fanout72/X fanout75/X VPWR VGND sg13g2_buf_1
Xfanout94 fanout94/X fanout97/X VPWR VGND sg13g2_buf_1
Xfanout83 fanout83/X fanout84/X VPWR VGND sg13g2_buf_1
X_253_ _253_/X _634_/Q _253_/B VPWR VGND sg13g2_and2_1
XFILLER_7_979 VPWR VGND sg13g2_decap_8
XFILLER_7_902 VPWR VGND sg13g2_decap_8
XFILLER_1_194 VPWR VGND sg13g2_fill_2
XFILLER_2_673 VPWR VGND sg13g2_decap_8
XFILLER_45_371 VPWR VGND sg13g2_decap_8
XFILLER_14_791 VPWR VGND sg13g2_decap_8
Xclkload20 clkload20/X _453_/A VPWR VGND sg13g2_buf_8
Xclkload3 clkload3/Y _610_/CLK VPWR VGND sg13g2_inv_1
XFILLER_35_809 VPWR VGND sg13g2_decap_8
XFILLER_47_658 VPWR VGND sg13g2_decap_8
Xdelaybuf_9_clk _458_/B delaybuf_9_clk/A VPWR VGND sg13g2_buf_16
X_305_ _472_/D _220_/Y _301_/Y _307_/B VPWR VGND sg13g2_a21oi_1
X_236_ _461_/D _236_/A0 _461_/Q _236_/S VPWR VGND sg13g2_mux2_1
XFILLER_7_776 VPWR VGND sg13g2_decap_8
XFILLER_6_297 VPWR VGND sg13g2_fill_2
XFILLER_2_470 VPWR VGND sg13g2_decap_8
XFILLER_3_982 VPWR VGND sg13g2_decap_8
XFILLER_46_680 VPWR VGND sg13g2_fill_2
XFILLER_14_1003 VPWR VGND sg13g2_decap_8
Xclkbuf_5_24__f_clk_regs _581_/CLK clkbuf_4_12_0_clk_regs/X VPWR VGND sg13g2_buf_16
XFILLER_1_908 VPWR VGND sg13g2_decap_8
XFILLER_29_15 VPWR VGND sg13g2_fill_1
XFILLER_40_823 VPWR VGND sg13g2_decap_8
XFILLER_4_757 VPWR VGND sg13g2_decap_8
XFILLER_0_930 VPWR VGND sg13g2_decap_8
XFILLER_48_901 VPWR VGND sg13g2_fill_1
XFILLER_47_455 VPWR VGND sg13g2_decap_8
X_219_ _304_/A _470_/Q VPWR VGND sg13g2_inv_1
XFILLER_7_573 VPWR VGND sg13g2_decap_8
XFILLER_18_0 VPWR VGND sg13g2_fill_2
XFILLER_22_823 VPWR VGND sg13g2_decap_8
Xclkbuf_5_8__f_clk_regs _649_/CLK clkbuf_4_4_0_clk_regs/X VPWR VGND sg13g2_buf_16
XFILLER_0_237 VPWR VGND sg13g2_decap_8
XFILLER_1_705 VPWR VGND sg13g2_decap_8
Xoutput27 uio_out[5] _246_/X VPWR VGND sg13g2_buf_1
Xoutput16 uio_oe[2] _251_/X VPWR VGND sg13g2_buf_1
X_570_ _570_/Q _570_/CLK _570_/D fanout95/X VPWR VGND sg13g2_dfrbpq_1
XFILLER_13_812 VPWR VGND sg13g2_decap_8
XFILLER_13_889 VPWR VGND sg13g2_decap_8
XFILLER_9_805 VPWR VGND sg13g2_decap_8
XFILLER_4_554 VPWR VGND sg13g2_decap_8
XFILLER_48_797 VPWR VGND sg13g2_decap_8
XFILLER_48_720 VPWR VGND sg13g2_decap_8
Xclkbuf_0_clk clkbuf_0_clk/X clk VPWR VGND sg13g2_buf_16
XFILLER_8_882 VPWR VGND sg13g2_decap_8
XFILLER_10_826 VPWR VGND sg13g2_decap_8
XFILLER_1_502 VPWR VGND sg13g2_decap_8
XFILLER_1_579 VPWR VGND sg13g2_decap_8
X_622_ _622_/Q _622_/CLK _622_/D fanout72/X VPWR VGND sg13g2_dfrbpq_1
XFILLER_49_539 VPWR VGND sg13g2_decap_8
XFILLER_44_277 VPWR VGND sg13g2_decap_8
XFILLER_45_756 VPWR VGND sg13g2_decap_8
X_553_ _553_/Q _570_/CLK _553_/D fanout96/X VPWR VGND sg13g2_dfrbpq_1
X_484_ _484_/Q _486_/CLK _484_/D fanout97/X VPWR VGND sg13g2_dfrbpq_1
XFILLER_5_863 VPWR VGND sg13g2_decap_8
XFILLER_36_756 VPWR VGND sg13g2_decap_8
XFILLER_48_594 VPWR VGND sg13g2_decap_8
XFILLER_17_981 VPWR VGND sg13g2_fill_1
Xhold123 _605_/D _578_/Q VPWR VGND sg13g2_dlygate4sd3_1
Xhold112 _616_/D _589_/Q VPWR VGND sg13g2_dlygate4sd3_1
Xhold101 _648_/D _259_/X VPWR VGND sg13g2_dlygate4sd3_1
XFILLER_27_756 VPWR VGND sg13g2_decap_8
XFILLER_42_737 VPWR VGND sg13g2_decap_8
XFILLER_2_855 VPWR VGND sg13g2_decap_8
Xclkbuf_2_3__f_clk_delayed _453_/A clkbuf_0_clk_delayed/X VPWR VGND sg13g2_buf_16
XFILLER_18_756 VPWR VGND sg13g2_decap_8
XFILLER_45_553 VPWR VGND sg13g2_decap_8
X_605_ _605_/Q _622_/CLK _605_/D fanout73/X VPWR VGND sg13g2_dfrbpq_1
XFILLER_49_336 VPWR VGND sg13g2_decap_8
XFILLER_14_940 VPWR VGND sg13g2_decap_8
XFILLER_41_792 VPWR VGND sg13g2_decap_8
X_536_ _536_/Q _609_/CLK _536_/D fanout74/X VPWR VGND sg13g2_dfrbpq_1
X_467_ _467_/Q _443_/Y _467_/D fanout77/X VPWR VGND sg13g2_dfrbpq_1
X_398_ _563_/D _562_/Q _563_/Q _398_/S VPWR VGND sg13g2_mux2_1
XFILLER_5_660 VPWR VGND sg13g2_decap_8
XFILLER_17_1023 VPWR VGND sg13g2_decap_4
XFILLER_32_770 VPWR VGND sg13g2_decap_8
XFILLER_46_317 VPWR VGND sg13g2_decap_8
XFILLER_11_910 VPWR VGND sg13g2_decap_8
XFILLER_15_759 VPWR VGND sg13g2_decap_8
XFILLER_23_792 VPWR VGND sg13g2_decap_8
Xfanout40 _435_/S _436_/S VPWR VGND sg13g2_buf_1
Xfanout51 _350_/S _332_/S VPWR VGND sg13g2_buf_1
Xfanout62 _253_/B _255_/B VPWR VGND sg13g2_buf_1
Xfanout73 fanout73/X fanout74/X VPWR VGND sg13g2_buf_1
X_321_ _486_/D _485_/Q _486_/Q _322_/S VPWR VGND sg13g2_mux2_1
X_252_ _252_/X _633_/Q _253_/B VPWR VGND sg13g2_and2_1
XFILLER_11_987 VPWR VGND sg13g2_decap_8
Xfanout95 fanout95/X fanout96/X VPWR VGND sg13g2_buf_1
Xfanout84 fanout84/X input1/X VPWR VGND sg13g2_buf_1
XFILLER_7_958 VPWR VGND sg13g2_decap_8
XFILLER_6_424 VPWR VGND sg13g2_fill_2
XFILLER_2_652 VPWR VGND sg13g2_decap_8
XFILLER_45_350 VPWR VGND sg13g2_decap_8
XFILLER_46_851 VPWR VGND sg13g2_fill_1
XFILLER_14_770 VPWR VGND sg13g2_decap_8
Xclkbuf_5_23__f_clk_regs _621_/CLK clkbuf_4_11_0_clk_regs/X VPWR VGND sg13g2_buf_16
Xclkload10 clkload10/Y _609_/CLK VPWR VGND sg13g2_inv_1
X_519_ _519_/Q _571_/CLK _519_/D fanout82/X VPWR VGND sg13g2_dfrbpq_1
XFILLER_48_0 VPWR VGND sg13g2_fill_1
XFILLER_20_795 VPWR VGND sg13g2_decap_8
Xclkload4 clkload4/Y _656_/CLK VPWR VGND sg13g2_inv_1
XFILLER_4_939 VPWR VGND sg13g2_decap_8
XFILLER_47_637 VPWR VGND sg13g2_decap_8
XFILLER_11_784 VPWR VGND sg13g2_decap_8
X_304_ _307_/B _304_/A _366_/S _304_/C VPWR VGND sg13g2_nor3_1
X_235_ _462_/D _235_/A0 _658_/D _236_/S VPWR VGND sg13g2_mux2_1
XFILLER_3_961 VPWR VGND sg13g2_decap_8
XFILLER_7_755 VPWR VGND sg13g2_decap_8
Xclkbuf_5_7__f_clk_regs _658_/CLK clkbuf_4_3_0_clk_regs/X VPWR VGND sg13g2_buf_16
XFILLER_0_419 VPWR VGND sg13g2_decap_8
XFILLER_44_629 VPWR VGND sg13g2_decap_8
XFILLER_40_802 VPWR VGND sg13g2_decap_8
XFILLER_4_736 VPWR VGND sg13g2_decap_8
XFILLER_0_986 VPWR VGND sg13g2_decap_8
Xclkbuf_regs_0_clk clkbuf_regs_0_clk/X delaybuf_28_clk/X VPWR VGND sg13g2_buf_16
XFILLER_48_957 VPWR VGND sg13g2_decap_4
XFILLER_47_434 VPWR VGND sg13g2_decap_8
XFILLER_43_695 VPWR VGND sg13g2_decap_4
XFILLER_31_846 VPWR VGND sg13g2_decap_4
X_218_ _218_/Y _469_/Q VPWR VGND sg13g2_inv_1
XFILLER_7_552 VPWR VGND sg13g2_decap_8
XFILLER_22_802 VPWR VGND sg13g2_decap_8
Xoutput28 uio_out[6] _247_/X VPWR VGND sg13g2_buf_1
Xoutput17 uio_oe[3] _252_/X VPWR VGND sg13g2_buf_1
XFILLER_5_1024 VPWR VGND sg13g2_decap_4
XFILLER_44_415 VPWR VGND sg13g2_decap_8
XFILLER_13_868 VPWR VGND sg13g2_decap_8
XFILLER_4_533 VPWR VGND sg13g2_decap_8
XFILLER_0_783 VPWR VGND sg13g2_decap_8
XFILLER_48_776 VPWR VGND sg13g2_decap_8
XFILLER_8_861 VPWR VGND sg13g2_decap_8
XFILLER_39_798 VPWR VGND sg13g2_decap_8
Xclkbuf_4_7_0_clk_regs clkbuf_4_7_0_clk_regs/X clkbuf_0_clk_regs/X VPWR VGND sg13g2_buf_8
XFILLER_10_805 VPWR VGND sg13g2_decap_8
XFILLER_5_308 VPWR VGND sg13g2_decap_8
XFILLER_1_558 VPWR VGND sg13g2_decap_8
XFILLER_45_735 VPWR VGND sg13g2_decap_8
X_621_ _621_/Q _621_/CLK _621_/D fanout85/X VPWR VGND sg13g2_dfrbpq_1
XFILLER_49_518 VPWR VGND sg13g2_decap_8
X_552_ _552_/Q _567_/CLK _552_/D fanout95/X VPWR VGND sg13g2_dfrbpq_1
X_483_ _483_/Q _486_/CLK _483_/D fanout97/X VPWR VGND sg13g2_dfrbpq_1
XFILLER_5_842 VPWR VGND sg13g2_decap_8
XFILLER_4_330 VPWR VGND sg13g2_fill_2
XFILLER_0_580 VPWR VGND sg13g2_decap_8
XFILLER_48_573 VPWR VGND sg13g2_decap_8
XFILLER_44_790 VPWR VGND sg13g2_decap_8
Xhold124 _653_/D _465_/Q VPWR VGND sg13g2_dlygate4sd3_1
Xhold113 _627_/D _598_/Q VPWR VGND sg13g2_dlygate4sd3_1
Xhold102 _657_/D _461_/Q VPWR VGND sg13g2_dlygate4sd3_1
XFILLER_2_1016 VPWR VGND sg13g2_decap_8
XFILLER_2_1027 VPWR VGND sg13g2_fill_2
XFILLER_42_716 VPWR VGND sg13g2_decap_8
XFILLER_6_639 VPWR VGND sg13g2_decap_8
XFILLER_2_834 VPWR VGND sg13g2_decap_8
XFILLER_49_315 VPWR VGND sg13g2_decap_8
X_535_ _535_/Q _649_/CLK _535_/D fanout82/X VPWR VGND sg13g2_dfrbpq_1
X_604_ _604_/Q _604_/CLK _604_/D fanout76/X VPWR VGND sg13g2_dfrbpq_1
XFILLER_14_996 VPWR VGND sg13g2_decap_8
XFILLER_41_771 VPWR VGND sg13g2_decap_8
Xclkbuf_5_22__f_clk_regs _606_/CLK clkbuf_4_11_0_clk_regs/X VPWR VGND sg13g2_buf_16
X_466_ _654_/D _442_/Y _466_/D fanout77/X VPWR VGND sg13g2_dfrbpq_1
X_397_ _562_/D _561_/Q _562_/Q _397_/S VPWR VGND sg13g2_mux2_1
XFILLER_49_882 VPWR VGND sg13g2_decap_8
XFILLER_24_749 VPWR VGND sg13g2_decap_8
XFILLER_48_392 VPWR VGND sg13g2_decap_8
Xdelaybuf_28_clk delaybuf_28_clk/X delaybuf_28_clk/A VPWR VGND sg13g2_buf_16
XFILLER_47_819 VPWR VGND sg13g2_decap_8
XFILLER_11_966 VPWR VGND sg13g2_decap_8
Xfanout41 _436_/S _376_/S VPWR VGND sg13g2_buf_1
Xfanout52 _332_/S _322_/S VPWR VGND sg13g2_buf_1
Xfanout63 _255_/B _237_/X VPWR VGND sg13g2_buf_1
Xfanout74 fanout74/X fanout75/X VPWR VGND sg13g2_buf_1
Xfanout96 fanout96/X fanout97/X VPWR VGND sg13g2_buf_1
Xfanout85 fanout85/X fanout90/X VPWR VGND sg13g2_buf_1
X_320_ _485_/D _484_/Q _485_/Q _369_/S VPWR VGND sg13g2_mux2_1
X_251_ _251_/X _632_/Q _253_/B VPWR VGND sg13g2_and2_1
XFILLER_2_631 VPWR VGND sg13g2_decap_8
Xdelaybuf_19_clk delaybuf_20_clk/A delaybuf_19_clk/A VPWR VGND sg13g2_buf_16
XFILLER_8_0 VPWR VGND sg13g2_fill_2
XFILLER_7_937 VPWR VGND sg13g2_decap_8
XFILLER_38_819 VPWR VGND sg13g2_decap_8
Xclkbuf_5_6__f_clk_regs _660_/CLK clkbuf_4_3_0_clk_regs/X VPWR VGND sg13g2_buf_16
X_518_ _518_/Q _649_/CLK _518_/D fanout81/X VPWR VGND sg13g2_dfrbpq_1
Xclkload11 clkload11/Y _630_/CLK VPWR VGND sg13g2_inv_1
X_449_ _449_/Y _456_/A _449_/B VPWR VGND sg13g2_xnor2_1
XFILLER_5_491 VPWR VGND sg13g2_fill_2
XFILLER_5_480 VPWR VGND sg13g2_decap_8
XFILLER_47_1028 VPWR VGND sg13g2_fill_1
XFILLER_29_819 VPWR VGND sg13g2_decap_4
Xclkload5 clkload5/Y _657_/CLK VPWR VGND sg13g2_inv_1
XFILLER_20_774 VPWR VGND sg13g2_decap_8
XFILLER_3_406 VPWR VGND sg13g2_decap_8
XFILLER_4_918 VPWR VGND sg13g2_decap_8
XFILLER_47_616 VPWR VGND sg13g2_decap_8
XFILLER_42_343 VPWR VGND sg13g2_decap_4
XFILLER_43_833 VPWR VGND sg13g2_decap_8
XFILLER_11_763 VPWR VGND sg13g2_decap_8
XFILLER_24_72 VPWR VGND sg13g2_fill_1
X_303_ _304_/C _469_/Q _471_/Q _472_/Q VPWR VGND sg13g2_nand3_1
X_234_ _463_/D _234_/A0 _463_/Q _236_/S VPWR VGND sg13g2_mux2_1
XFILLER_7_734 VPWR VGND sg13g2_decap_8
XFILLER_3_940 VPWR VGND sg13g2_decap_8
XFILLER_34_800 VPWR VGND sg13g2_fill_1
XFILLER_25_833 VPWR VGND sg13g2_decap_8
XFILLER_44_608 VPWR VGND sg13g2_decap_8
Xclkbuf_0__017__regs clkbuf_0__017__regs/X clkbuf_regs_1_clk/X VPWR VGND sg13g2_buf_16
XFILLER_4_715 VPWR VGND sg13g2_decap_8
XFILLER_0_965 VPWR VGND sg13g2_decap_8
XFILLER_47_413 VPWR VGND sg13g2_decap_8
XFILLER_16_844 VPWR VGND sg13g2_decap_8
XFILLER_43_641 VPWR VGND sg13g2_fill_1
XFILLER_43_674 VPWR VGND sg13g2_decap_8
XFILLER_7_531 VPWR VGND sg13g2_decap_8
Xoutput29 uio_out[7] _248_/X VPWR VGND sg13g2_buf_1
Xoutput18 uio_oe[4] _253_/X VPWR VGND sg13g2_buf_1
XFILLER_5_1003 VPWR VGND sg13g2_decap_8
XFILLER_13_847 VPWR VGND sg13g2_decap_8
XFILLER_4_512 VPWR VGND sg13g2_decap_8
XFILLER_0_762 VPWR VGND sg13g2_decap_8
XFILLER_4_589 VPWR VGND sg13g2_decap_8
XFILLER_48_755 VPWR VGND sg13g2_decap_8
XFILLER_47_287 VPWR VGND sg13g2_decap_8
XFILLER_47_254 VPWR VGND sg13g2_fill_1
XFILLER_8_840 VPWR VGND sg13g2_decap_8
XFILLER_11_1008 VPWR VGND sg13g2_decap_8
XFILLER_7_97 VPWR VGND sg13g2_fill_2
XFILLER_39_777 VPWR VGND sg13g2_decap_8
XFILLER_1_537 VPWR VGND sg13g2_decap_8
XFILLER_45_714 VPWR VGND sg13g2_decap_8
X_551_ _551_/Q _551_/CLK _551_/D fanout94/X VPWR VGND sg13g2_dfrbpq_1
X_620_ _620_/Q _621_/CLK _620_/D fanout85/X VPWR VGND sg13g2_dfrbpq_1
Xclkbuf_5_21__f_clk_regs _622_/CLK clkbuf_4_10_0_clk_regs/X VPWR VGND sg13g2_buf_16
X_482_ _482_/Q _551_/CLK _482_/D fanout97/X VPWR VGND sg13g2_dfrbpq_1
XFILLER_32_72 VPWR VGND sg13g2_fill_1
XFILLER_5_898 VPWR VGND sg13g2_decap_8
XFILLER_5_821 VPWR VGND sg13g2_decap_8
XFILLER_48_552 VPWR VGND sg13g2_decap_8
Xhold125 _612_/D _585_/Q VPWR VGND sg13g2_dlygate4sd3_1
Xhold114 _655_/D _467_/Q VPWR VGND sg13g2_dlygate4sd3_1
Xhold103 _650_/D _658_/Q VPWR VGND sg13g2_dlygate4sd3_1
XFILLER_2_813 VPWR VGND sg13g2_decap_8
XFILLER_6_618 VPWR VGND sg13g2_decap_8
Xclkbuf_5_5__f_clk_regs _657_/CLK clkbuf_4_2_0_clk_regs/X VPWR VGND sg13g2_buf_16
XFILLER_26_791 VPWR VGND sg13g2_decap_8
XFILLER_45_588 VPWR VGND sg13g2_decap_8
X_534_ _534_/Q _571_/CLK _534_/D fanout91/X VPWR VGND sg13g2_dfrbpq_1
X_603_ _603_/Q _604_/CLK _603_/D fanout76/X VPWR VGND sg13g2_dfrbpq_1
X_465_ _465_/Q _441_/Y _465_/D fanout79/X VPWR VGND sg13g2_dfrbpq_1
XFILLER_14_975 VPWR VGND sg13g2_decap_8
XFILLER_41_750 VPWR VGND sg13g2_decap_8
X_396_ _561_/D _560_/Q _561_/Q _397_/S VPWR VGND sg13g2_mux2_1
XFILLER_5_695 VPWR VGND sg13g2_decap_8
XFILLER_4_183 VPWR VGND sg13g2_decap_8
XFILLER_49_861 VPWR VGND sg13g2_decap_8
XFILLER_48_371 VPWR VGND sg13g2_decap_8
XFILLER_17_791 VPWR VGND sg13g2_decap_8
XFILLER_11_945 VPWR VGND sg13g2_decap_8
XFILLER_23_761 VPWR VGND sg13g2_decap_4
XFILLER_42_569 VPWR VGND sg13g2_decap_8
Xfanout42 _375_/S _376_/S VPWR VGND sg13g2_buf_1
Xfanout53 _369_/S _322_/S VPWR VGND sg13g2_buf_1
Xfanout64 fanout64/X fanout66/X VPWR VGND sg13g2_buf_1
Xfanout75 fanout75/X fanout84/X VPWR VGND sg13g2_buf_1
Xfanout97 fanout97/X input1/X VPWR VGND sg13g2_buf_1
Xfanout86 fanout86/X fanout87/X VPWR VGND sg13g2_buf_1
X_250_ _250_/X _631_/Q _253_/B VPWR VGND sg13g2_and2_1
XFILLER_7_916 VPWR VGND sg13g2_decap_8
XFILLER_6_426 VPWR VGND sg13g2_fill_1
XFILLER_2_610 VPWR VGND sg13g2_decap_8
XFILLER_2_687 VPWR VGND sg13g2_decap_8
XFILLER_46_842 VPWR VGND sg13g2_decap_8
XFILLER_45_385 VPWR VGND sg13g2_decap_8
X_517_ _517_/Q _604_/CLK _517_/D fanout77/X VPWR VGND sg13g2_dfrbpq_1
X_448_ _448_/Y _453_/A _459_/B VPWR VGND sg13g2_xnor2_1
Xclkload12 clkload12/Y _622_/CLK VPWR VGND sg13g2_inv_1
X_379_ _544_/D _543_/Q _544_/Q _391_/S VPWR VGND sg13g2_mux2_1
XFILLER_6_982 VPWR VGND sg13g2_decap_8
XFILLER_47_1007 VPWR VGND sg13g2_decap_8
Xclkload6 clkload6/Y _658_/CLK VPWR VGND sg13g2_inv_1
XFILLER_8_1001 VPWR VGND sg13g2_fill_2
XFILLER_43_812 VPWR VGND sg13g2_decap_8
X_302_ _471_/D _471_/Q _302_/B VPWR VGND sg13g2_xnor2_1
X_233_ _464_/D _233_/A0 _464_/Q _236_/S VPWR VGND sg13g2_mux2_1
XFILLER_7_713 VPWR VGND sg13g2_decap_8
XFILLER_6_223 VPWR VGND sg13g2_decap_8
XFILLER_6_212 VPWR VGND sg13g2_fill_1
XFILLER_2_484 VPWR VGND sg13g2_decap_8
XFILLER_3_996 VPWR VGND sg13g2_decap_8
XFILLER_34_845 VPWR VGND sg13g2_decap_8
XFILLER_14_1017 VPWR VGND sg13g2_decap_8
XFILLER_14_1028 VPWR VGND sg13g2_fill_1
XFILLER_25_812 VPWR VGND sg13g2_decap_8
XFILLER_40_837 VPWR VGND sg13g2_decap_8
XFILLER_0_944 VPWR VGND sg13g2_decap_8
XFILLER_16_823 VPWR VGND sg13g2_decap_8
XFILLER_47_469 VPWR VGND sg13g2_decap_8
XFILLER_7_587 VPWR VGND sg13g2_decap_8
XFILLER_7_510 VPWR VGND sg13g2_decap_8
XFILLER_3_793 VPWR VGND sg13g2_decap_8
XFILLER_22_837 VPWR VGND sg13g2_decap_8
XFILLER_0_207 VPWR VGND sg13g2_fill_2
XFILLER_1_719 VPWR VGND sg13g2_decap_8
Xoutput19 uio_oe[5] _254_/X VPWR VGND sg13g2_buf_1
XFILLER_13_826 VPWR VGND sg13g2_decap_8
Xclkbuf_5_20__f_clk_regs _629_/CLK clkbuf_4_10_0_clk_regs/X VPWR VGND sg13g2_buf_16
XFILLER_9_819 VPWR VGND sg13g2_decap_8
XFILLER_4_568 VPWR VGND sg13g2_decap_8
XFILLER_0_741 VPWR VGND sg13g2_decap_8
XFILLER_48_734 VPWR VGND sg13g2_decap_8
XFILLER_7_351 VPWR VGND sg13g2_decap_8
XFILLER_7_32 VPWR VGND sg13g2_fill_2
XFILLER_3_590 VPWR VGND sg13g2_decap_8
XFILLER_8_896 VPWR VGND sg13g2_decap_8
XFILLER_39_756 VPWR VGND sg13g2_decap_8
XFILLER_1_516 VPWR VGND sg13g2_decap_8
Xclkbuf_5_4__f_clk_regs _604_/CLK clkbuf_4_2_0_clk_regs/X VPWR VGND sg13g2_buf_16
X_550_ _550_/Q _562_/CLK _550_/D fanout94/X VPWR VGND sg13g2_dfrbpq_1
X_481_ _481_/Q _486_/CLK _481_/D fanout91/X VPWR VGND sg13g2_dfrbpq_1
XFILLER_5_877 VPWR VGND sg13g2_decap_8
XFILLER_5_800 VPWR VGND sg13g2_decap_8
XFILLER_4_343 VPWR VGND sg13g2_decap_8
XFILLER_4_332 VPWR VGND sg13g2_fill_1
XFILLER_48_531 VPWR VGND sg13g2_decap_8
Xhold126 _606_/D _579_/Q VPWR VGND sg13g2_dlygate4sd3_1
Xhold115 _623_/D _594_/Q VPWR VGND sg13g2_dlygate4sd3_1
Xhold104 _652_/D _660_/Q VPWR VGND sg13g2_dlygate4sd3_1
XFILLER_35_770 VPWR VGND sg13g2_decap_8
XFILLER_2_869 VPWR VGND sg13g2_decap_8
X_602_ _602_/Q _657_/CLK _602_/D fanout81/X VPWR VGND sg13g2_dfrbpq_1
XFILLER_14_910 VPWR VGND sg13g2_decap_8
XFILLER_14_954 VPWR VGND sg13g2_fill_1
XFILLER_26_770 VPWR VGND sg13g2_decap_8
XFILLER_45_567 VPWR VGND sg13g2_decap_8
X_533_ _533_/Q _577_/CLK _533_/D fanout83/X VPWR VGND sg13g2_dfrbpq_1
X_464_ _464_/Q _440_/Y _464_/D fanout78/X VPWR VGND sg13g2_dfrbpq_1
X_395_ _560_/D _559_/Q _560_/Q _398_/S VPWR VGND sg13g2_mux2_1
XFILLER_1_880 VPWR VGND sg13g2_decap_8
XFILLER_5_674 VPWR VGND sg13g2_decap_8
XFILLER_49_840 VPWR VGND sg13g2_decap_8
XFILLER_48_350 VPWR VGND sg13g2_decap_8
XFILLER_17_770 VPWR VGND sg13g2_decap_8
XFILLER_32_784 VPWR VGND sg13g2_decap_8
XFILLER_32_795 VPWR VGND sg13g2_fill_1
XFILLER_9_980 VPWR VGND sg13g2_decap_8
XFILLER_11_924 VPWR VGND sg13g2_decap_8
Xfanout43 _429_/S _428_/S VPWR VGND sg13g2_buf_1
Xfanout54 _322_/S fanout60/X VPWR VGND sg13g2_buf_1
Xfanout65 fanout65/X fanout66/X VPWR VGND sg13g2_buf_1
Xfanout76 fanout76/X fanout81/X VPWR VGND sg13g2_buf_1
Xfanout87 fanout87/X fanout90/X VPWR VGND sg13g2_buf_1
XFILLER_2_666 VPWR VGND sg13g2_decap_8
XFILLER_8_2 VPWR VGND sg13g2_fill_1
XFILLER_45_320 VPWR VGND sg13g2_decap_4
XFILLER_46_821 VPWR VGND sg13g2_decap_8
XFILLER_14_784 VPWR VGND sg13g2_decap_8
XFILLER_45_364 VPWR VGND sg13g2_decap_8
X_516_ _516_/Q _604_/CLK _516_/D fanout77/X VPWR VGND sg13g2_dfrbpq_1
X_447_ _447_/Y _453_/A _459_/B VPWR VGND sg13g2_xnor2_1
X_378_ _543_/D _542_/Q _543_/Q _391_/S VPWR VGND sg13g2_mux2_1
Xclkload13 clkload13/Y _621_/CLK VPWR VGND sg13g2_inv_1
XFILLER_6_961 VPWR VGND sg13g2_decap_8
Xclkload7 clkload7/Y _577_/CLK VPWR VGND sg13g2_inv_1
X_301_ _301_/Y _469_/Q _470_/Q _471_/Q _311_/S VPWR VGND sg13g2_nand4_1
X_232_ _236_/S _647_/Q _648_/Q VPWR VGND sg13g2_nand2b_1
XFILLER_11_798 VPWR VGND sg13g2_decap_8
XFILLER_7_769 VPWR VGND sg13g2_decap_8
XFILLER_2_463 VPWR VGND sg13g2_decap_8
XFILLER_3_975 VPWR VGND sg13g2_decap_8
XFILLER_46_695 VPWR VGND sg13g2_decap_8
XFILLER_46_662 VPWR VGND sg13g2_decap_8
XFILLER_40_816 VPWR VGND sg13g2_decap_8
XFILLER_0_923 VPWR VGND sg13g2_decap_8
XFILLER_16_802 VPWR VGND sg13g2_decap_8
XFILLER_43_632 VPWR VGND sg13g2_decap_8
XFILLER_47_448 VPWR VGND sg13g2_decap_8
XFILLER_16_879 VPWR VGND sg13g2_fill_2
XFILLER_31_805 VPWR VGND sg13g2_decap_4
XFILLER_3_772 VPWR VGND sg13g2_decap_8
XFILLER_7_566 VPWR VGND sg13g2_decap_8
XFILLER_2_271 VPWR VGND sg13g2_decap_8
XFILLER_22_816 VPWR VGND sg13g2_decap_8
Xclkbuf_5_3__f_clk_regs _656_/CLK clkbuf_4_1_0_clk_regs/X VPWR VGND sg13g2_buf_16
XFILLER_44_429 VPWR VGND sg13g2_decap_8
XFILLER_13_805 VPWR VGND sg13g2_decap_8
XFILLER_4_547 VPWR VGND sg13g2_decap_8
XFILLER_0_720 VPWR VGND sg13g2_decap_8
XFILLER_0_797 VPWR VGND sg13g2_decap_8
XFILLER_48_713 VPWR VGND sg13g2_decap_8
XFILLER_43_451 VPWR VGND sg13g2_decap_8
XFILLER_12_882 VPWR VGND sg13g2_decap_8
XFILLER_8_875 VPWR VGND sg13g2_decap_8
XFILLER_10_819 VPWR VGND sg13g2_decap_8
XFILLER_45_749 VPWR VGND sg13g2_decap_8
X_480_ _480_/Q _556_/CLK _480_/D fanout91/X VPWR VGND sg13g2_dfrbpq_1
XFILLER_5_856 VPWR VGND sg13g2_decap_8
XFILLER_0_594 VPWR VGND sg13g2_decap_8
XFILLER_36_749 VPWR VGND sg13g2_decap_8
XFILLER_48_587 VPWR VGND sg13g2_decap_8
XFILLER_43_292 VPWR VGND sg13g2_decap_4
Xhold127 _610_/D _583_/Q VPWR VGND sg13g2_dlygate4sd3_1
Xhold116 _611_/D _584_/Q VPWR VGND sg13g2_dlygate4sd3_1
Xhold105 _651_/D _659_/Q VPWR VGND sg13g2_dlygate4sd3_1
XFILLER_27_749 VPWR VGND sg13g2_decap_8
XFILLER_2_848 VPWR VGND sg13g2_decap_8
XFILLER_18_749 VPWR VGND sg13g2_decap_8
XFILLER_45_546 VPWR VGND sg13g2_decap_8
X_601_ _601_/Q _629_/CLK _601_/D fanout67/X VPWR VGND sg13g2_dfrbpq_1
XFILLER_49_329 VPWR VGND sg13g2_decap_8
XFILLER_41_785 VPWR VGND sg13g2_decap_8
X_532_ _532_/Q _649_/CLK _532_/D fanout83/X VPWR VGND sg13g2_dfrbpq_1
X_463_ _463_/Q _439_/Y _463_/D fanout78/X VPWR VGND sg13g2_dfrbpq_1
X_394_ _559_/D _558_/Q _559_/Q _397_/S VPWR VGND sg13g2_mux2_1
Xclkbuf_4_6_0_clk_regs clkbuf_4_6_0_clk_regs/X clkbuf_0_clk_regs/X VPWR VGND sg13g2_buf_8
XFILLER_5_653 VPWR VGND sg13g2_decap_8
XFILLER_49_896 VPWR VGND sg13g2_decap_8
XFILLER_17_1016 VPWR VGND sg13g2_decap_8
XFILLER_17_1027 VPWR VGND sg13g2_fill_2
XFILLER_32_763 VPWR VGND sg13g2_decap_8
XFILLER_11_903 VPWR VGND sg13g2_decap_8
Xfanout44 _428_/S _376_/S VPWR VGND sg13g2_buf_1
Xfanout55 _397_/S _398_/S VPWR VGND sg13g2_buf_1
Xfanout66 fanout66/X fanout68/X VPWR VGND sg13g2_buf_1
Xfanout77 fanout77/X fanout81/X VPWR VGND sg13g2_buf_1
Xfanout88 fanout88/X fanout90/X VPWR VGND sg13g2_buf_1
XFILLER_2_645 VPWR VGND sg13g2_decap_8
XFILLER_45_343 VPWR VGND sg13g2_decap_8
X_515_ _515_/Q _515_/CLK _515_/D fanout88/X VPWR VGND sg13g2_dfrbpq_1
XFILLER_46_800 VPWR VGND sg13g2_decap_8
XFILLER_14_763 VPWR VGND sg13g2_decap_8
XFILLER_41_582 VPWR VGND sg13g2_decap_8
X_446_ _446_/Y _453_/A _449_/B VPWR VGND sg13g2_xnor2_1
X_377_ _542_/D _541_/Q _542_/Q _398_/S VPWR VGND sg13g2_mux2_1
XFILLER_10_980 VPWR VGND sg13g2_decap_8
Xclkload14 clkload14/Y _513_/CLK VPWR VGND sg13g2_inv_1
XFILLER_6_940 VPWR VGND sg13g2_decap_8
XFILLER_5_450 VPWR VGND sg13g2_fill_2
XFILLER_49_693 VPWR VGND sg13g2_decap_8
XFILLER_20_788 VPWR VGND sg13g2_decap_8
Xclkload8 clkload8/Y _571_/CLK VPWR VGND sg13g2_inv_1
XFILLER_8_1003 VPWR VGND sg13g2_fill_1
XFILLER_28_811 VPWR VGND sg13g2_decap_8
XFILLER_43_847 VPWR VGND sg13g2_decap_4
X_300_ _470_/D _302_/B _300_/B VPWR VGND sg13g2_and2_1
X_231_ _465_/D _236_/A0 _465_/Q _231_/S VPWR VGND sg13g2_mux2_1
XFILLER_11_777 VPWR VGND sg13g2_decap_8
XFILLER_3_954 VPWR VGND sg13g2_decap_8
XFILLER_7_748 VPWR VGND sg13g2_decap_8
XFILLER_2_442 VPWR VGND sg13g2_decap_8
XFILLER_46_641 VPWR VGND sg13g2_decap_8
X_429_ _594_/D _622_/D _594_/Q _429_/S VPWR VGND sg13g2_mux2_1
Xclkbuf_5_2__f_clk_regs _626_/CLK clkbuf_4_1_0_clk_regs/X VPWR VGND sg13g2_buf_16
Xinput1 input1/X rst_n VPWR VGND sg13g2_buf_1
XFILLER_49_490 VPWR VGND sg13g2_decap_8
XFILLER_25_847 VPWR VGND sg13g2_decap_4
XFILLER_4_729 VPWR VGND sg13g2_decap_8
XFILLER_0_902 VPWR VGND sg13g2_decap_8
XFILLER_0_979 VPWR VGND sg13g2_decap_8
XFILLER_10_66 VPWR VGND sg13g2_fill_2
XFILLER_47_427 VPWR VGND sg13g2_decap_8
XFILLER_16_858 VPWR VGND sg13g2_fill_2
XFILLER_43_611 VPWR VGND sg13g2_decap_8
XFILLER_43_688 VPWR VGND sg13g2_decap_8
XFILLER_43_699 VPWR VGND sg13g2_fill_2
XFILLER_7_545 VPWR VGND sg13g2_decap_8
XFILLER_3_751 VPWR VGND sg13g2_decap_8
XFILLER_47_972 VPWR VGND sg13g2_fill_1
XFILLER_46_471 VPWR VGND sg13g2_decap_8
XFILLER_0_209 VPWR VGND sg13g2_fill_1
XFILLER_5_1028 VPWR VGND sg13g2_fill_1
XFILLER_5_1017 VPWR VGND sg13g2_decap_8
XFILLER_44_408 VPWR VGND sg13g2_decap_8
Xdelaybuf_2_clk delaybuf_2_clk/X clkload0/A VPWR VGND sg13g2_buf_16
XFILLER_4_526 VPWR VGND sg13g2_decap_8
XFILLER_0_776 VPWR VGND sg13g2_decap_8
XFILLER_48_769 VPWR VGND sg13g2_decap_8
XFILLER_47_224 VPWR VGND sg13g2_fill_2
XFILLER_12_861 VPWR VGND sg13g2_decap_8
XFILLER_8_854 VPWR VGND sg13g2_decap_8
XFILLER_47_791 VPWR VGND sg13g2_decap_8
XFILLER_45_728 VPWR VGND sg13g2_decap_8
XFILLER_38_791 VPWR VGND sg13g2_decap_8
XFILLER_10_1022 VPWR VGND sg13g2_decap_8
XFILLER_5_835 VPWR VGND sg13g2_decap_8
XFILLER_0_573 VPWR VGND sg13g2_decap_8
XFILLER_4_367 VPWR VGND sg13g2_decap_8
XFILLER_48_511 VPWR VGND sg13g2_fill_2
XFILLER_17_942 VPWR VGND sg13g2_decap_8
XFILLER_29_791 VPWR VGND sg13g2_decap_8
XFILLER_48_566 VPWR VGND sg13g2_decap_8
XFILLER_43_271 VPWR VGND sg13g2_decap_8
XFILLER_44_783 VPWR VGND sg13g2_decap_8
Xhold128 _259_/A _643_/Q VPWR VGND sg13g2_dlygate4sd3_1
Xhold117 _619_/D _590_/Q VPWR VGND sg13g2_dlygate4sd3_1
Xhold106 _659_/D _463_/Q VPWR VGND sg13g2_dlygate4sd3_1
XFILLER_2_1009 VPWR VGND sg13g2_decap_8
XFILLER_4_890 VPWR VGND sg13g2_decap_8
XFILLER_42_709 VPWR VGND sg13g2_decap_8
XFILLER_2_827 VPWR VGND sg13g2_decap_8
XFILLER_49_308 VPWR VGND sg13g2_decap_8
X_600_ _629_/D _630_/CLK _600_/D fanout64/X VPWR VGND sg13g2_dfrbpq_1
X_531_ _531_/Q _576_/CLK _531_/D fanout81/X VPWR VGND sg13g2_dfrbpq_1
XFILLER_14_989 VPWR VGND sg13g2_decap_8
XFILLER_41_764 VPWR VGND sg13g2_decap_8
X_462_ _658_/D _438_/Y _462_/D fanout79/X VPWR VGND sg13g2_dfrbpq_1
X_393_ _558_/D _557_/Q _558_/Q _397_/S VPWR VGND sg13g2_mux2_1
XFILLER_5_632 VPWR VGND sg13g2_decap_8
XFILLER_4_79 VPWR VGND sg13g2_fill_2
XFILLER_49_875 VPWR VGND sg13g2_decap_8
XFILLER_1_1020 VPWR VGND sg13g2_decap_8
XFILLER_44_580 VPWR VGND sg13g2_decap_8
XFILLER_48_385 VPWR VGND sg13g2_decap_8
XFILLER_11_959 VPWR VGND sg13g2_decap_8
Xfanout45 _376_/S fanout60/X VPWR VGND sg13g2_buf_1
Xfanout56 _398_/S _392_/S VPWR VGND sg13g2_buf_1
Xfanout67 fanout67/X fanout68/X VPWR VGND sg13g2_buf_1
Xfanout89 fanout89/X fanout90/X VPWR VGND sg13g2_buf_1
Xfanout78 fanout78/X fanout80/X VPWR VGND sg13g2_buf_1
XFILLER_2_624 VPWR VGND sg13g2_decap_8
XFILLER_45_399 VPWR VGND sg13g2_decap_8
X_514_ _514_/Q _515_/CLK _514_/D fanout88/X VPWR VGND sg13g2_dfrbpq_1
Xclkload15 clkload15/Y _498_/CLK VPWR VGND sg13g2_inv_1
X_445_ _445_/Y _456_/A _452_/B VPWR VGND sg13g2_xnor2_1
X_376_ _541_/D _540_/Q _541_/Q _376_/S VPWR VGND sg13g2_mux2_1
Xclkbuf_5_1__f_clk_regs _610_/CLK clkbuf_4_0_0_clk_regs/X VPWR VGND sg13g2_buf_16
XFILLER_6_996 VPWR VGND sg13g2_decap_8
XFILLER_37_812 VPWR VGND sg13g2_decap_8
XFILLER_37_823 VPWR VGND sg13g2_fill_2
XFILLER_49_672 VPWR VGND sg13g2_decap_8
Xclkload9 clkload9/Y _567_/CLK VPWR VGND sg13g2_inv_1
XFILLER_47_609 VPWR VGND sg13g2_decap_8
XFILLER_43_826 VPWR VGND sg13g2_decap_8
XFILLER_11_756 VPWR VGND sg13g2_decap_8
XFILLER_42_347 VPWR VGND sg13g2_fill_2
Xclkbuf_1_1__f__017__regs _257__99/A clkbuf_0__017__regs/X VPWR VGND sg13g2_buf_16
X_230_ _466_/D _235_/A0 _654_/D _231_/S VPWR VGND sg13g2_mux2_1
XFILLER_7_727 VPWR VGND sg13g2_decap_8
XFILLER_3_933 VPWR VGND sg13g2_decap_8
XFILLER_19_823 VPWR VGND sg13g2_fill_2
XFILLER_2_498 VPWR VGND sg13g2_decap_8
XFILLER_46_620 VPWR VGND sg13g2_decap_8
X_428_ _593_/D _592_/Q _622_/D _428_/S VPWR VGND sg13g2_mux2_1
X_359_ _524_/D _523_/Q _524_/Q _435_/S VPWR VGND sg13g2_mux2_1
XFILLER_6_793 VPWR VGND sg13g2_decap_8
XFILLER_25_826 VPWR VGND sg13g2_decap_8
Xinput2 _291_/B ui_in[0] VPWR VGND sg13g2_buf_1
XFILLER_4_708 VPWR VGND sg13g2_decap_8
XFILLER_0_958 VPWR VGND sg13g2_decap_8
XFILLER_48_929 VPWR VGND sg13g2_fill_1
XFILLER_47_406 VPWR VGND sg13g2_decap_8
XFILLER_16_837 VPWR VGND sg13g2_decap_8
XFILLER_43_667 VPWR VGND sg13g2_decap_8
XFILLER_7_524 VPWR VGND sg13g2_decap_8
XFILLER_3_730 VPWR VGND sg13g2_decap_8
XFILLER_46_450 VPWR VGND sg13g2_decap_8
XFILLER_15_892 VPWR VGND sg13g2_decap_8
XFILLER_6_590 VPWR VGND sg13g2_decap_8
XFILLER_4_505 VPWR VGND sg13g2_decap_8
XFILLER_0_755 VPWR VGND sg13g2_decap_8
XFILLER_48_748 VPWR VGND sg13g2_decap_8
XFILLER_12_840 VPWR VGND sg13g2_decap_8
XFILLER_43_420 VPWR VGND sg13g2_decap_4
XFILLER_46_96 VPWR VGND sg13g2_fill_1
XFILLER_8_833 VPWR VGND sg13g2_decap_8
XFILLER_47_770 VPWR VGND sg13g2_decap_8
XFILLER_38_770 VPWR VGND sg13g2_decap_8
XFILLER_45_707 VPWR VGND sg13g2_decap_8
XFILLER_10_1001 VPWR VGND sg13g2_decap_8
XFILLER_5_814 VPWR VGND sg13g2_decap_8
XFILLER_0_552 VPWR VGND sg13g2_decap_8
XFILLER_48_545 VPWR VGND sg13g2_decap_8
XFILLER_17_921 VPWR VGND sg13g2_decap_4
XFILLER_29_770 VPWR VGND sg13g2_decap_8
XFILLER_44_762 VPWR VGND sg13g2_decap_8
Xhold118 _621_/D _592_/Q VPWR VGND sg13g2_dlygate4sd3_1
Xhold107 _630_/D _601_/Q VPWR VGND sg13g2_dlygate4sd3_1
XFILLER_7_162 VPWR VGND sg13g2_decap_8
XFILLER_2_806 VPWR VGND sg13g2_decap_8
XFILLER_14_924 VPWR VGND sg13g2_decap_4
XFILLER_26_784 VPWR VGND sg13g2_decap_8
X_530_ _530_/Q _604_/CLK _530_/D fanout77/X VPWR VGND sg13g2_dfrbpq_1
X_461_ _461_/Q _461_/CLK _461_/D fanout79/X VPWR VGND sg13g2_dfrbpq_1
XFILLER_41_743 VPWR VGND sg13g2_decap_8
X_392_ _557_/D _556_/Q _557_/Q _392_/S VPWR VGND sg13g2_mux2_1
Xclkbuf_5_0__f_clk_regs _611_/CLK clkbuf_4_0_0_clk_regs/X VPWR VGND sg13g2_buf_16
XFILLER_5_688 VPWR VGND sg13g2_decap_8
XFILLER_5_611 VPWR VGND sg13g2_decap_8
XFILLER_1_894 VPWR VGND sg13g2_decap_8
XFILLER_49_854 VPWR VGND sg13g2_decap_8
XFILLER_48_364 VPWR VGND sg13g2_decap_8
XFILLER_17_784 VPWR VGND sg13g2_decap_8
X_659_ _659_/Q _660_/CLK _659_/D fanout78/X VPWR VGND sg13g2_dfrbpq_1
XFILLER_9_994 VPWR VGND sg13g2_decap_8
XFILLER_11_938 VPWR VGND sg13g2_decap_8
Xfanout46 _411_/S _412_/S VPWR VGND sg13g2_buf_1
Xfanout57 _405_/S _391_/S VPWR VGND sg13g2_buf_1
Xfanout68 fanout68/X fanout75/X VPWR VGND sg13g2_buf_1
Xfanout79 fanout79/X fanout80/X VPWR VGND sg13g2_buf_1
XFILLER_7_909 VPWR VGND sg13g2_decap_8
XFILLER_1_102 VPWR VGND sg13g2_fill_2
XFILLER_2_603 VPWR VGND sg13g2_decap_8
XFILLER_46_835 VPWR VGND sg13g2_decap_8
XFILLER_45_378 VPWR VGND sg13g2_decap_8
X_513_ _513_/Q _513_/CLK _513_/D fanout88/X VPWR VGND sg13g2_dfrbpq_1
X_444_ _444_/Y _460_/A _460_/B VPWR VGND sg13g2_xnor2_1
XFILLER_14_798 VPWR VGND sg13g2_decap_8
Xclkload16 clkload16/Y _563_/CLK VPWR VGND sg13g2_inv_1
X_375_ _540_/D _539_/Q _540_/Q _375_/S VPWR VGND sg13g2_mux2_1
XFILLER_6_975 VPWR VGND sg13g2_decap_8
XFILLER_5_452 VPWR VGND sg13g2_fill_1
XFILLER_1_691 VPWR VGND sg13g2_decap_8
XFILLER_49_651 VPWR VGND sg13g2_decap_8
XFILLER_9_791 VPWR VGND sg13g2_decap_8
XFILLER_43_805 VPWR VGND sg13g2_decap_8
XFILLER_7_706 VPWR VGND sg13g2_decap_8
XFILLER_2_477 VPWR VGND sg13g2_decap_8
XFILLER_3_912 VPWR VGND sg13g2_decap_8
XFILLER_3_989 VPWR VGND sg13g2_decap_8
XFILLER_19_802 VPWR VGND sg13g2_decap_8
XFILLER_46_676 VPWR VGND sg13g2_decap_4
XFILLER_34_838 VPWR VGND sg13g2_decap_8
X_427_ _592_/D _591_/Q _592_/Q _427_/S VPWR VGND sg13g2_mux2_1
X_358_ _523_/D _522_/Q _523_/Q _435_/S VPWR VGND sg13g2_mux2_1
X_289_ _289_/Y _226_/Y _258_/A _288_/Y VPWR VGND sg13g2_o21ai_1
XFILLER_6_772 VPWR VGND sg13g2_decap_8
Xdelaybuf_21_clk delaybuf_22_clk/A delaybuf_21_clk/A VPWR VGND sg13g2_buf_16
XFILLER_25_805 VPWR VGND sg13g2_decap_8
Xinput3 input3/X ui_in[1] VPWR VGND sg13g2_buf_1
XFILLER_0_937 VPWR VGND sg13g2_decap_8
XFILLER_10_68 VPWR VGND sg13g2_fill_1
XFILLER_16_816 VPWR VGND sg13g2_decap_8
XFILLER_19_11 VPWR VGND sg13g2_fill_2
Xdelaybuf_12_clk delaybuf_13_clk/A delaybuf_12_clk/A VPWR VGND sg13g2_buf_16
XFILLER_7_503 VPWR VGND sg13g2_decap_8
XFILLER_2_285 VPWR VGND sg13g2_decap_4
XFILLER_3_786 VPWR VGND sg13g2_decap_8
XFILLER_15_871 VPWR VGND sg13g2_decap_8
Xclkbuf_1_0__f__017_ _258_/B clkbuf_0__017_/X VPWR VGND sg13g2_buf_16
XFILLER_13_819 VPWR VGND sg13g2_decap_8
XFILLER_21_34 VPWR VGND sg13g2_fill_2
XFILLER_0_734 VPWR VGND sg13g2_decap_8
XFILLER_48_727 VPWR VGND sg13g2_decap_8
XFILLER_12_896 VPWR VGND sg13g2_decap_8
XFILLER_8_812 VPWR VGND sg13g2_decap_8
XFILLER_8_889 VPWR VGND sg13g2_decap_8
XFILLER_7_399 VPWR VGND sg13g2_fill_2
XFILLER_7_344 VPWR VGND sg13g2_decap_8
XFILLER_39_749 VPWR VGND sg13g2_decap_8
XFILLER_3_583 VPWR VGND sg13g2_decap_8
XFILLER_1_509 VPWR VGND sg13g2_decap_8
XFILLER_0_531 VPWR VGND sg13g2_decap_8
XFILLER_48_524 VPWR VGND sg13g2_decap_8
XFILLER_48_513 VPWR VGND sg13g2_fill_1
XFILLER_44_741 VPWR VGND sg13g2_decap_8
Xhold108 _614_/D _587_/Q VPWR VGND sg13g2_dlygate4sd3_1
Xhold119 _607_/D _580_/Q VPWR VGND sg13g2_dlygate4sd3_1
XFILLER_35_763 VPWR VGND sg13g2_decap_8
XFILLER_14_903 VPWR VGND sg13g2_decap_8
XFILLER_14_947 VPWR VGND sg13g2_decap_8
XFILLER_26_763 VPWR VGND sg13g2_decap_8
XFILLER_41_722 VPWR VGND sg13g2_decap_8
X_460_ _460_/Y _460_/A _460_/B VPWR VGND sg13g2_xnor2_1
X_391_ _556_/D _555_/Q _556_/Q _391_/S VPWR VGND sg13g2_mux2_1
XFILLER_41_799 VPWR VGND sg13g2_decap_8
XFILLER_5_667 VPWR VGND sg13g2_decap_8
XFILLER_0_372 VPWR VGND sg13g2_fill_2
XFILLER_1_873 VPWR VGND sg13g2_decap_8
XFILLER_49_833 VPWR VGND sg13g2_decap_8
XFILLER_48_343 VPWR VGND sg13g2_decap_8
XFILLER_13_980 VPWR VGND sg13g2_decap_8
XFILLER_17_763 VPWR VGND sg13g2_decap_8
XFILLER_32_777 VPWR VGND sg13g2_decap_8
X_589_ _589_/Q _623_/CLK _589_/D fanout71/X VPWR VGND sg13g2_dfrbpq_1
X_658_ _658_/Q _658_/CLK _658_/D fanout79/X VPWR VGND sg13g2_dfrbpq_1
XFILLER_9_973 VPWR VGND sg13g2_decap_8
XFILLER_11_917 VPWR VGND sg13g2_decap_8
XFILLER_13_35 VPWR VGND sg13g2_fill_1
XFILLER_23_799 VPWR VGND sg13g2_decap_8
Xfanout47 _412_/S _366_/S VPWR VGND sg13g2_buf_1
Xfanout58 _391_/S _392_/S VPWR VGND sg13g2_buf_1
Xfanout69 fanout69/X fanout70/X VPWR VGND sg13g2_buf_1
XFILLER_2_659 VPWR VGND sg13g2_decap_8
XFILLER_45_313 VPWR VGND sg13g2_decap_8
XFILLER_46_814 VPWR VGND sg13g2_decap_8
XFILLER_14_777 VPWR VGND sg13g2_decap_8
XFILLER_45_357 VPWR VGND sg13g2_decap_8
X_512_ _512_/Q _513_/CLK _512_/D fanout88/X VPWR VGND sg13g2_dfrbpq_1
X_443_ _443_/Y _453_/A _459_/B VPWR VGND sg13g2_xnor2_1
X_374_ _539_/D _538_/Q _539_/Q _375_/S VPWR VGND sg13g2_mux2_1
XFILLER_10_994 VPWR VGND sg13g2_decap_8
XFILLER_41_596 VPWR VGND sg13g2_decap_8
Xclkload17 clkload17/Y _257__99/A VPWR VGND sg13g2_inv_1
XFILLER_6_954 VPWR VGND sg13g2_decap_8
XFILLER_1_670 VPWR VGND sg13g2_decap_8
XFILLER_49_630 VPWR VGND sg13g2_decap_8
Xclkbuf_leaf_0_clk _459_/B delaybuf_2_clk/X VPWR VGND sg13g2_buf_8
XFILLER_9_770 VPWR VGND sg13g2_decap_8
Xclkbuf_4_5_0_clk_regs clkbuf_4_5_0_clk_regs/X clkbuf_0_clk_regs/X VPWR VGND sg13g2_buf_8
XFILLER_2_456 VPWR VGND sg13g2_decap_8
XFILLER_3_968 VPWR VGND sg13g2_decap_8
XFILLER_45_187 VPWR VGND sg13g2_fill_2
XFILLER_46_655 VPWR VGND sg13g2_decap_8
X_426_ _591_/D _590_/Q _591_/Q _428_/S VPWR VGND sg13g2_mux2_1
X_357_ _522_/D _521_/Q _522_/Q _411_/S VPWR VGND sg13g2_mux2_1
XFILLER_10_791 VPWR VGND sg13g2_decap_8
X_288_ _288_/Y _288_/A1 _279_/Y _281_/Y _288_/B2 VPWR VGND sg13g2_a22oi_1
XFILLER_6_751 VPWR VGND sg13g2_decap_8
Xinput4 _281_/A ui_in[2] VPWR VGND sg13g2_buf_1
XFILLER_40_809 VPWR VGND sg13g2_decap_8
XFILLER_0_916 VPWR VGND sg13g2_decap_8
XFILLER_43_625 VPWR VGND sg13g2_decap_8
XFILLER_13_1022 VPWR VGND sg13g2_decap_8
Xdelaybuf_5_clk delaybuf_6_clk/A delaybuf_5_clk/A VPWR VGND sg13g2_buf_16
XFILLER_7_559 VPWR VGND sg13g2_decap_8
XFILLER_2_242 VPWR VGND sg13g2_fill_2
XFILLER_3_765 VPWR VGND sg13g2_decap_8
XFILLER_15_850 VPWR VGND sg13g2_decap_8
XFILLER_22_809 VPWR VGND sg13g2_decap_8
X_409_ _574_/D _573_/Q _574_/Q _411_/S VPWR VGND sg13g2_mux2_1
XFILLER_2_92 VPWR VGND sg13g2_fill_1
XFILLER_0_713 VPWR VGND sg13g2_decap_8
XFILLER_48_706 VPWR VGND sg13g2_decap_8
XFILLER_47_238 VPWR VGND sg13g2_fill_2
XFILLER_12_875 VPWR VGND sg13g2_decap_8
XFILLER_8_868 VPWR VGND sg13g2_decap_8
XFILLER_3_562 VPWR VGND sg13g2_decap_8
XFILLER_46_282 VPWR VGND sg13g2_decap_8
XFILLER_0_510 VPWR VGND sg13g2_decap_8
XFILLER_5_849 VPWR VGND sg13g2_decap_8
XFILLER_0_587 VPWR VGND sg13g2_decap_8
XFILLER_17_956 VPWR VGND sg13g2_fill_2
XFILLER_43_285 VPWR VGND sg13g2_decap_8
XFILLER_44_720 VPWR VGND sg13g2_decap_8
XFILLER_44_797 VPWR VGND sg13g2_decap_8
Xhold109 _649_/D _657_/Q VPWR VGND sg13g2_dlygate4sd3_1
XFILLER_41_701 VPWR VGND sg13g2_decap_8
XFILLER_45_539 VPWR VGND sg13g2_decap_8
X_390_ _555_/D _554_/Q _555_/Q _391_/S VPWR VGND sg13g2_mux2_1
XFILLER_41_778 VPWR VGND sg13g2_decap_8
XFILLER_5_646 VPWR VGND sg13g2_decap_8
XFILLER_1_852 VPWR VGND sg13g2_decap_8
XFILLER_49_812 VPWR VGND sg13g2_decap_8
X_657_ _657_/Q _657_/CLK _657_/D fanout79/X VPWR VGND sg13g2_dfrbpq_1
XFILLER_49_889 VPWR VGND sg13g2_decap_8
XFILLER_48_399 VPWR VGND sg13g2_decap_8
XFILLER_48_322 VPWR VGND sg13g2_decap_8
XFILLER_17_1009 VPWR VGND sg13g2_decap_8
XFILLER_32_756 VPWR VGND sg13g2_decap_8
XFILLER_44_594 VPWR VGND sg13g2_decap_8
X_588_ _588_/Q _623_/CLK _588_/D fanout67/X VPWR VGND sg13g2_dfrbpq_1
XFILLER_9_952 VPWR VGND sg13g2_decap_8
XFILLER_23_756 VPWR VGND sg13g2_fill_1
Xfanout48 _366_/S fanout60/X VPWR VGND sg13g2_buf_1
Xfanout59 _392_/S fanout60/X VPWR VGND sg13g2_buf_1
XFILLER_2_638 VPWR VGND sg13g2_decap_8
X_511_ _511_/Q _513_/CLK _511_/D fanout87/X VPWR VGND sg13g2_dfrbpq_1
XFILLER_14_756 VPWR VGND sg13g2_decap_8
XFILLER_41_575 VPWR VGND sg13g2_decap_8
X_442_ _442_/Y _460_/A _460_/B VPWR VGND sg13g2_xnor2_1
X_373_ _538_/D _537_/Q _538_/Q _375_/S VPWR VGND sg13g2_mux2_1
XFILLER_10_973 VPWR VGND sg13g2_decap_8
Xclkload18 clkload18/Y _460_/A VPWR VGND sg13g2_inv_1
XFILLER_6_933 VPWR VGND sg13g2_decap_8
XFILLER_5_487 VPWR VGND sg13g2_decap_4
XFILLER_5_443 VPWR VGND sg13g2_decap_8
XFILLER_44_380 VPWR VGND sg13g2_decap_8
XFILLER_49_686 VPWR VGND sg13g2_decap_8
XFILLER_28_804 VPWR VGND sg13g2_decap_8
XFILLER_3_947 VPWR VGND sg13g2_decap_8
XFILLER_46_634 VPWR VGND sg13g2_decap_8
XFILLER_10_770 VPWR VGND sg13g2_decap_8
XFILLER_42_851 VPWR VGND sg13g2_fill_1
X_425_ _590_/D _589_/Q _590_/Q _428_/S VPWR VGND sg13g2_mux2_1
X_356_ _521_/D _520_/Q _521_/Q _412_/S VPWR VGND sg13g2_mux2_1
X_287_ _287_/Y _225_/Y _258_/A _286_/Y VPWR VGND sg13g2_o21ai_1
XFILLER_6_730 VPWR VGND sg13g2_decap_8
XFILLER_46_5 VPWR VGND sg13g2_fill_1
Xinput5 _279_/B ui_in[3] VPWR VGND sg13g2_buf_1
XFILLER_49_483 VPWR VGND sg13g2_decap_8
XFILLER_24_840 VPWR VGND sg13g2_decap_8
XFILLER_43_604 VPWR VGND sg13g2_decap_8
XFILLER_13_1001 VPWR VGND sg13g2_decap_8
XFILLER_24_851 VPWR VGND sg13g2_fill_1
XFILLER_7_538 VPWR VGND sg13g2_decap_8
XFILLER_3_744 VPWR VGND sg13g2_decap_8
X_408_ _573_/D _572_/Q _573_/Q _411_/S VPWR VGND sg13g2_mux2_1
XFILLER_46_464 VPWR VGND sg13g2_decap_8
X_339_ _504_/D _503_/Q _504_/Q _416_/S VPWR VGND sg13g2_mux2_1
XFILLER_49_280 VPWR VGND sg13g2_decap_8
X_257__98 _648_/CLK _461_/CLK VPWR VGND sg13g2_inv_1
XFILLER_4_519 VPWR VGND sg13g2_decap_8
XFILLER_0_769 VPWR VGND sg13g2_decap_8
XFILLER_43_478 VPWR VGND sg13g2_fill_2
XFILLER_12_854 VPWR VGND sg13g2_decap_8
XFILLER_8_847 VPWR VGND sg13g2_decap_8
XFILLER_7_49 VPWR VGND sg13g2_fill_1
XFILLER_7_324 VPWR VGND sg13g2_fill_1
XFILLER_3_541 VPWR VGND sg13g2_decap_8
XFILLER_47_784 VPWR VGND sg13g2_decap_8
XFILLER_38_784 VPWR VGND sg13g2_decap_8
XFILLER_10_1015 VPWR VGND sg13g2_decap_8
XFILLER_5_828 VPWR VGND sg13g2_decap_8
XFILLER_0_566 VPWR VGND sg13g2_decap_8
XFILLER_17_935 VPWR VGND sg13g2_decap_8
XFILLER_29_784 VPWR VGND sg13g2_decap_8
XFILLER_48_559 VPWR VGND sg13g2_decap_8
XFILLER_48_504 VPWR VGND sg13g2_decap_8
XFILLER_17_979 VPWR VGND sg13g2_fill_2
XFILLER_44_776 VPWR VGND sg13g2_decap_8
XFILLER_7_176 VPWR VGND sg13g2_fill_2
XFILLER_4_883 VPWR VGND sg13g2_decap_8
XFILLER_47_581 VPWR VGND sg13g2_decap_8
XFILLER_26_798 VPWR VGND sg13g2_decap_8
XFILLER_41_757 VPWR VGND sg13g2_decap_8
XFILLER_5_625 VPWR VGND sg13g2_decap_8
XFILLER_49_1022 VPWR VGND sg13g2_decap_8
XFILLER_0_341 VPWR VGND sg13g2_decap_4
XFILLER_0_374 VPWR VGND sg13g2_fill_1
XFILLER_0_385 VPWR VGND sg13g2_decap_8
XFILLER_1_831 VPWR VGND sg13g2_decap_8
XFILLER_49_868 VPWR VGND sg13g2_decap_8
XFILLER_48_301 VPWR VGND sg13g2_decap_8
XFILLER_17_798 VPWR VGND sg13g2_decap_8
XFILLER_1_1013 VPWR VGND sg13g2_decap_8
XFILLER_44_573 VPWR VGND sg13g2_decap_8
X_587_ _587_/Q _623_/CLK _587_/D fanout64/X VPWR VGND sg13g2_dfrbpq_1
X_656_ _656_/Q _656_/CLK _656_/D fanout70/X VPWR VGND sg13g2_dfrbpq_1
XFILLER_48_378 VPWR VGND sg13g2_decap_8
XFILLER_9_931 VPWR VGND sg13g2_decap_8
XFILLER_4_680 VPWR VGND sg13g2_decap_8
XFILLER_12_0 VPWR VGND sg13g2_fill_1
XFILLER_48_890 VPWR VGND sg13g2_decap_8
Xfanout38 _278_/S _275_/S VPWR VGND sg13g2_buf_1
Xfanout49 _427_/S _322_/S VPWR VGND sg13g2_buf_1
XFILLER_2_617 VPWR VGND sg13g2_decap_8
Xclkbuf_5_31__f_clk_regs _551_/CLK clkbuf_4_15_0_clk_regs/X VPWR VGND sg13g2_buf_16
X_510_ _510_/Q _609_/CLK _510_/D fanout85/X VPWR VGND sg13g2_dfrbpq_1
X_441_ _441_/Y _441_/A _458_/B VPWR VGND sg13g2_xnor2_1
XFILLER_46_849 VPWR VGND sg13g2_fill_2
XFILLER_10_952 VPWR VGND sg13g2_decap_8
X_372_ _537_/D _536_/Q _537_/Q _429_/S VPWR VGND sg13g2_mux2_1
XFILLER_6_912 VPWR VGND sg13g2_decap_8
Xclkload19 clkload19/Y _456_/A VPWR VGND sg13g2_inv_1
XFILLER_6_989 VPWR VGND sg13g2_decap_8
XFILLER_0_182 VPWR VGND sg13g2_decap_8
XFILLER_37_805 VPWR VGND sg13g2_decap_8
XFILLER_49_665 VPWR VGND sg13g2_decap_8
X_639_ _639_/Q _453_/Y _639_/D fanout74/X VPWR VGND sg13g2_dfrbpq_1
Xdelaybuf_24_clk delaybuf_25_clk/A delaybuf_24_clk/A VPWR VGND sg13g2_buf_16
XFILLER_43_819 VPWR VGND sg13g2_decap_8
XFILLER_11_749 VPWR VGND sg13g2_decap_8
XFILLER_6_208 VPWR VGND sg13g2_decap_4
XFILLER_2_403 VPWR VGND sg13g2_fill_2
XFILLER_3_926 VPWR VGND sg13g2_decap_8
Xdelaybuf_15_clk delaybuf_16_clk/A delaybuf_15_clk/A VPWR VGND sg13g2_buf_16
XFILLER_19_816 VPWR VGND sg13g2_decap_8
XFILLER_46_613 VPWR VGND sg13g2_decap_8
X_424_ _589_/D _588_/Q _589_/Q _436_/S VPWR VGND sg13g2_mux2_1
X_355_ _520_/D _519_/Q _520_/Q _412_/S VPWR VGND sg13g2_mux2_1
X_286_ _286_/Y _286_/A1 _279_/Y _281_/Y _286_/B2 VPWR VGND sg13g2_a22oi_1
XFILLER_2_981 VPWR VGND sg13g2_decap_8
XFILLER_6_786 VPWR VGND sg13g2_decap_8
XFILLER_5_241 VPWR VGND sg13g2_decap_8
XFILLER_25_819 VPWR VGND sg13g2_decap_8
Xinput6 _603_/D ui_in[4] VPWR VGND sg13g2_buf_1
XFILLER_49_462 VPWR VGND sg13g2_decap_8
XFILLER_7_517 VPWR VGND sg13g2_decap_8
XFILLER_2_299 VPWR VGND sg13g2_decap_8
XFILLER_3_723 VPWR VGND sg13g2_decap_8
Xclkbuf_2_2__f_clk_delayed _456_/A clkbuf_0_clk_delayed/X VPWR VGND sg13g2_buf_16
XFILLER_46_443 VPWR VGND sg13g2_decap_8
XFILLER_47_933 VPWR VGND sg13g2_fill_2
XFILLER_15_885 VPWR VGND sg13g2_decap_8
X_407_ _572_/D _571_/Q _572_/Q _411_/S VPWR VGND sg13g2_mux2_1
X_338_ _503_/D _502_/Q _503_/Q _416_/S VPWR VGND sg13g2_mux2_1
X_269_ _641_/D _607_/Q _621_/Q _275_/S VPWR VGND sg13g2_mux2_1
XFILLER_6_583 VPWR VGND sg13g2_decap_8
X_257__99 _647_/CLK _257__99/A VPWR VGND sg13g2_inv_1
XFILLER_0_748 VPWR VGND sg13g2_decap_8
XFILLER_12_833 VPWR VGND sg13g2_decap_8
XFILLER_43_413 VPWR VGND sg13g2_decap_8
XFILLER_43_424 VPWR VGND sg13g2_fill_2
XFILLER_3_520 VPWR VGND sg13g2_decap_8
XFILLER_8_826 VPWR VGND sg13g2_decap_8
XFILLER_7_303 VPWR VGND sg13g2_fill_1
XFILLER_3_597 VPWR VGND sg13g2_decap_8
XFILLER_47_763 VPWR VGND sg13g2_decap_8
XFILLER_7_881 VPWR VGND sg13g2_decap_8
XFILLER_38_763 VPWR VGND sg13g2_decap_8
XFILLER_5_807 VPWR VGND sg13g2_decap_8
XFILLER_0_545 VPWR VGND sg13g2_decap_8
XFILLER_17_914 VPWR VGND sg13g2_decap_8
XFILLER_17_958 VPWR VGND sg13g2_fill_1
XFILLER_29_763 VPWR VGND sg13g2_decap_8
XFILLER_44_755 VPWR VGND sg13g2_decap_8
XFILLER_48_538 VPWR VGND sg13g2_decap_8
XFILLER_3_372 VPWR VGND sg13g2_decap_8
XFILLER_4_862 VPWR VGND sg13g2_decap_8
XFILLER_21_5 VPWR VGND sg13g2_fill_2
XFILLER_35_777 VPWR VGND sg13g2_fill_1
XFILLER_47_560 VPWR VGND sg13g2_decap_8
Xclkbuf_5_30__f_clk_regs _486_/CLK clkbuf_4_15_0_clk_regs/X VPWR VGND sg13g2_buf_16
XFILLER_14_917 VPWR VGND sg13g2_decap_8
XFILLER_14_928 VPWR VGND sg13g2_fill_2
XFILLER_26_777 VPWR VGND sg13g2_decap_8
XFILLER_41_736 VPWR VGND sg13g2_decap_8
XFILLER_1_810 VPWR VGND sg13g2_decap_8
XFILLER_5_604 VPWR VGND sg13g2_decap_8
XFILLER_49_1001 VPWR VGND sg13g2_decap_8
XFILLER_1_887 VPWR VGND sg13g2_decap_8
XFILLER_49_847 VPWR VGND sg13g2_decap_8
XFILLER_48_357 VPWR VGND sg13g2_decap_8
XFILLER_17_777 VPWR VGND sg13g2_decap_8
XFILLER_44_552 VPWR VGND sg13g2_decap_8
X_586_ _586_/Q _615_/CLK _586_/D fanout64/X VPWR VGND sg13g2_dfrbpq_1
X_655_ _655_/Q _656_/CLK _655_/D fanout77/X VPWR VGND sg13g2_dfrbpq_1
XFILLER_13_994 VPWR VGND sg13g2_decap_8
XFILLER_9_987 VPWR VGND sg13g2_decap_8
XFILLER_9_910 VPWR VGND sg13g2_decap_8
Xclkbuf_leaf_3_clk _440_/B clkload0/A VPWR VGND sg13g2_buf_8
Xfanout39 _275_/S _646_/Q VPWR VGND sg13g2_buf_1
XFILLER_31_791 VPWR VGND sg13g2_decap_8
X_440_ _440_/Y _441_/A _440_/B VPWR VGND sg13g2_xnor2_1
X_371_ _536_/D _535_/Q _536_/Q _429_/S VPWR VGND sg13g2_mux2_1
XFILLER_46_828 VPWR VGND sg13g2_decap_8
XFILLER_10_931 VPWR VGND sg13g2_decap_8
XFILLER_6_968 VPWR VGND sg13g2_decap_8
XFILLER_1_684 VPWR VGND sg13g2_decap_8
XFILLER_49_644 VPWR VGND sg13g2_decap_8
X_569_ _569_/Q _570_/CLK _569_/D fanout95/X VPWR VGND sg13g2_dfrbpq_1
X_638_ _638_/Q _452_/Y _638_/D fanout71/X VPWR VGND sg13g2_dfrbpq_1
XFILLER_13_791 VPWR VGND sg13g2_decap_8
XFILLER_9_784 VPWR VGND sg13g2_decap_8
XFILLER_5_94 VPWR VGND sg13g2_fill_1
XFILLER_3_905 VPWR VGND sg13g2_decap_8
XFILLER_42_842 VPWR VGND sg13g2_decap_8
X_423_ _588_/D _587_/Q _588_/Q _436_/S VPWR VGND sg13g2_mux2_1
X_354_ _519_/D _518_/Q _519_/Q _411_/S VPWR VGND sg13g2_mux2_1
XFILLER_46_669 VPWR VGND sg13g2_decap_8
Xdelaybuf_8_clk delaybuf_9_clk/A delaybuf_8_clk/A VPWR VGND sg13g2_buf_16
X_285_ _285_/Y _224_/Y _258_/A _284_/Y VPWR VGND sg13g2_o21ai_1
XFILLER_6_765 VPWR VGND sg13g2_decap_8
XFILLER_1_481 VPWR VGND sg13g2_decap_8
XFILLER_2_960 VPWR VGND sg13g2_decap_8
XFILLER_49_441 VPWR VGND sg13g2_decap_8
Xinput7 _604_/D ui_in[5] VPWR VGND sg13g2_buf_1
XFILLER_16_809 VPWR VGND sg13g2_decap_8
XFILLER_43_639 VPWR VGND sg13g2_fill_2
XFILLER_3_702 VPWR VGND sg13g2_decap_8
XFILLER_2_278 VPWR VGND sg13g2_decap_8
XFILLER_3_779 VPWR VGND sg13g2_decap_8
XFILLER_46_422 VPWR VGND sg13g2_decap_8
XFILLER_15_864 VPWR VGND sg13g2_decap_8
XFILLER_30_812 VPWR VGND sg13g2_decap_8
XFILLER_30_845 VPWR VGND sg13g2_decap_8
Xclkbuf_4_4_0_clk_regs clkbuf_4_4_0_clk_regs/X clkbuf_0_clk_regs/X VPWR VGND sg13g2_buf_8
X_406_ _571_/D _570_/Q _571_/Q _411_/S VPWR VGND sg13g2_mux2_1
X_337_ _502_/D _501_/Q _502_/Q _427_/S VPWR VGND sg13g2_mux2_1
X_268_ _640_/D _606_/Q _620_/Q _275_/S VPWR VGND sg13g2_mux2_1
XFILLER_6_562 VPWR VGND sg13g2_decap_8
XFILLER_2_40 VPWR VGND sg13g2_fill_1
XFILLER_2_73 VPWR VGND sg13g2_fill_1
XFILLER_21_812 VPWR VGND sg13g2_decap_8
XFILLER_21_823 VPWR VGND sg13g2_fill_2
XFILLER_0_727 VPWR VGND sg13g2_decap_8
XFILLER_12_812 VPWR VGND sg13g2_decap_8
XFILLER_12_889 VPWR VGND sg13g2_decap_8
XFILLER_43_458 VPWR VGND sg13g2_decap_4
XFILLER_8_805 VPWR VGND sg13g2_decap_8
XFILLER_2_0 VPWR VGND sg13g2_fill_2
XFILLER_7_337 VPWR VGND sg13g2_decap_8
XFILLER_3_576 VPWR VGND sg13g2_decap_8
XFILLER_4_1023 VPWR VGND sg13g2_decap_4
XFILLER_46_296 VPWR VGND sg13g2_decap_8
XFILLER_47_742 VPWR VGND sg13g2_decap_8
Xinput10 _236_/A0 uio_in[0] VPWR VGND sg13g2_buf_1
XFILLER_7_860 VPWR VGND sg13g2_decap_8
XFILLER_0_524 VPWR VGND sg13g2_decap_8
XFILLER_48_517 VPWR VGND sg13g2_decap_8
XFILLER_44_734 VPWR VGND sg13g2_decap_8
XFILLER_7_178 VPWR VGND sg13g2_fill_1
XFILLER_4_841 VPWR VGND sg13g2_decap_8
XFILLER_16_992 VPWR VGND sg13g2_decap_8
XFILLER_35_756 VPWR VGND sg13g2_decap_8
XFILLER_26_756 VPWR VGND sg13g2_decap_8
XFILLER_41_715 VPWR VGND sg13g2_decap_8
XFILLER_0_365 VPWR VGND sg13g2_decap_8
XFILLER_1_866 VPWR VGND sg13g2_decap_8
X_654_ _654_/Q _656_/CLK _654_/D fanout70/X VPWR VGND sg13g2_dfrbpq_1
XFILLER_49_826 VPWR VGND sg13g2_decap_8
XFILLER_48_336 VPWR VGND sg13g2_decap_8
XFILLER_17_756 VPWR VGND sg13g2_decap_8
X_585_ _585_/Q _611_/CLK _585_/D fanout65/X VPWR VGND sg13g2_dfrbpq_1
XFILLER_13_973 VPWR VGND sg13g2_decap_8
XFILLER_40_781 VPWR VGND sg13g2_decap_8
XFILLER_9_966 VPWR VGND sg13g2_decap_8
XFILLER_31_770 VPWR VGND sg13g2_decap_8
XFILLER_45_306 VPWR VGND sg13g2_decap_8
XFILLER_46_807 VPWR VGND sg13g2_decap_8
X_370_ _535_/D _534_/Q _535_/Q _412_/S VPWR VGND sg13g2_mux2_1
XFILLER_10_910 VPWR VGND sg13g2_decap_8
XFILLER_10_987 VPWR VGND sg13g2_decap_8
XFILLER_22_781 VPWR VGND sg13g2_decap_8
XFILLER_41_589 VPWR VGND sg13g2_decap_8
XFILLER_6_947 VPWR VGND sg13g2_decap_8
XFILLER_1_663 VPWR VGND sg13g2_decap_8
XFILLER_49_623 VPWR VGND sg13g2_decap_8
XFILLER_45_840 VPWR VGND sg13g2_decap_8
XFILLER_45_851 VPWR VGND sg13g2_fill_1
X_637_ _637_/Q _451_/Y _637_/D fanout68/X VPWR VGND sg13g2_dfrbpq_1
XFILLER_13_770 VPWR VGND sg13g2_decap_8
XFILLER_44_394 VPWR VGND sg13g2_decap_8
X_568_ _568_/Q _570_/CLK _568_/D fanout95/X VPWR VGND sg13g2_dfrbpq_1
X_499_ _499_/Q _515_/CLK _499_/D fanout88/X VPWR VGND sg13g2_dfrbpq_1
XFILLER_9_763 VPWR VGND sg13g2_decap_8
XFILLER_28_818 VPWR VGND sg13g2_decap_8
XFILLER_2_449 VPWR VGND sg13g2_decap_8
XFILLER_27_851 VPWR VGND sg13g2_fill_1
XFILLER_46_648 VPWR VGND sg13g2_decap_8
XFILLER_41_364 VPWR VGND sg13g2_fill_2
XFILLER_42_821 VPWR VGND sg13g2_decap_8
X_422_ _587_/D _586_/Q _587_/Q _435_/S VPWR VGND sg13g2_mux2_1
X_353_ _518_/D _517_/Q _518_/Q _366_/S VPWR VGND sg13g2_mux2_1
X_284_ _284_/Y _284_/A1 _279_/Y _281_/Y _284_/B2 VPWR VGND sg13g2_a22oi_1
XFILLER_10_784 VPWR VGND sg13g2_decap_8
XFILLER_6_744 VPWR VGND sg13g2_decap_8
XFILLER_1_460 VPWR VGND sg13g2_decap_8
Xinput8 _617_/D ui_in[6] VPWR VGND sg13g2_buf_1
XFILLER_7_1021 VPWR VGND sg13g2_decap_8
XFILLER_49_420 VPWR VGND sg13g2_decap_8
XFILLER_49_497 VPWR VGND sg13g2_decap_8
XFILLER_0_909 VPWR VGND sg13g2_decap_8
XFILLER_43_618 VPWR VGND sg13g2_decap_8
XFILLER_13_1015 VPWR VGND sg13g2_decap_8
XFILLER_3_758 VPWR VGND sg13g2_decap_8
XFILLER_15_843 VPWR VGND sg13g2_decap_8
XFILLER_46_401 VPWR VGND sg13g2_decap_8
XFILLER_46_478 VPWR VGND sg13g2_decap_8
X_405_ _570_/D _569_/Q _570_/Q _405_/S VPWR VGND sg13g2_mux2_1
X_336_ _501_/D _500_/Q _501_/Q _350_/S VPWR VGND sg13g2_mux2_1
X_267_ _639_/D _605_/Q _619_/Q _275_/S VPWR VGND sg13g2_mux2_1
XFILLER_6_541 VPWR VGND sg13g2_decap_8
XFILLER_49_294 VPWR VGND sg13g2_decap_8
XFILLER_0_706 VPWR VGND sg13g2_decap_8
XFILLER_12_868 VPWR VGND sg13g2_decap_8
XFILLER_3_555 VPWR VGND sg13g2_decap_8
XFILLER_4_1002 VPWR VGND sg13g2_decap_8
XFILLER_47_721 VPWR VGND sg13g2_decap_8
XFILLER_46_253 VPWR VGND sg13g2_fill_2
XFILLER_46_275 VPWR VGND sg13g2_decap_8
XFILLER_47_798 VPWR VGND sg13g2_decap_8
Xinput11 _235_/A0 uio_in[1] VPWR VGND sg13g2_buf_1
X_319_ _484_/D _483_/Q _484_/Q _392_/S VPWR VGND sg13g2_mux2_1
XFILLER_28_0 VPWR VGND sg13g2_fill_2
Xclkbuf_1_0__f_clk delaybuf_10_clk/A clkbuf_0_clk/X VPWR VGND sg13g2_buf_16
XFILLER_38_798 VPWR VGND sg13g2_decap_8
XFILLER_0_503 VPWR VGND sg13g2_decap_8
XFILLER_17_949 VPWR VGND sg13g2_decap_8
XFILLER_29_798 VPWR VGND sg13g2_decap_8
XFILLER_43_278 VPWR VGND sg13g2_decap_8
XFILLER_44_713 VPWR VGND sg13g2_decap_8
XFILLER_4_820 VPWR VGND sg13g2_decap_8
XFILLER_4_897 VPWR VGND sg13g2_decap_8
XFILLER_47_595 VPWR VGND sg13g2_decap_8
XFILLER_43_37 VPWR VGND sg13g2_fill_1
XFILLER_5_639 VPWR VGND sg13g2_decap_8
XFILLER_1_845 VPWR VGND sg13g2_decap_8
XFILLER_49_805 VPWR VGND sg13g2_decap_8
XFILLER_1_1027 VPWR VGND sg13g2_fill_2
X_653_ _653_/Q _660_/CLK _653_/D fanout79/X VPWR VGND sg13g2_dfrbpq_1
XFILLER_48_315 VPWR VGND sg13g2_decap_8
XFILLER_13_952 VPWR VGND sg13g2_decap_8
XFILLER_32_749 VPWR VGND sg13g2_decap_8
XFILLER_44_587 VPWR VGND sg13g2_decap_8
X_584_ _584_/Q _610_/CLK _584_/D fanout65/X VPWR VGND sg13g2_dfrbpq_1
XFILLER_9_945 VPWR VGND sg13g2_decap_8
XFILLER_4_694 VPWR VGND sg13g2_decap_8
XFILLER_23_749 VPWR VGND sg13g2_decap_8
XFILLER_48_860 VPWR VGND sg13g2_decap_4
XFILLER_47_392 VPWR VGND sg13g2_decap_8
Xdelaybuf_27_clk delaybuf_28_clk/A delaybuf_27_clk/A VPWR VGND sg13g2_buf_16
XFILLER_14_749 VPWR VGND sg13g2_decap_8
XFILLER_41_568 VPWR VGND sg13g2_decap_8
XFILLER_10_966 VPWR VGND sg13g2_decap_8
Xdelaybuf_18_clk delaybuf_19_clk/A delaybuf_18_clk/A VPWR VGND sg13g2_buf_16
XFILLER_6_926 VPWR VGND sg13g2_decap_8
XFILLER_1_642 VPWR VGND sg13g2_decap_8
XFILLER_49_602 VPWR VGND sg13g2_decap_8
XFILLER_37_819 VPWR VGND sg13g2_decap_4
XFILLER_44_373 VPWR VGND sg13g2_decap_8
X_567_ _567_/Q _567_/CLK _567_/D fanout95/X VPWR VGND sg13g2_dfrbpq_1
X_636_ _636_/Q _450_/Y _636_/D fanout67/X VPWR VGND sg13g2_dfrbpq_1
XFILLER_49_679 VPWR VGND sg13g2_decap_8
X_498_ _498_/Q _498_/CLK _498_/D fanout88/X VPWR VGND sg13g2_dfrbpq_1
XFILLER_10_0 VPWR VGND sg13g2_fill_2
XFILLER_36_841 VPWR VGND sg13g2_decap_8
XFILLER_42_800 VPWR VGND sg13g2_decap_8
X_421_ _586_/D _585_/Q _586_/Q _435_/S VPWR VGND sg13g2_mux2_1
XFILLER_46_627 VPWR VGND sg13g2_decap_8
XFILLER_10_763 VPWR VGND sg13g2_decap_8
X_352_ _517_/D _516_/Q _517_/Q _366_/S VPWR VGND sg13g2_mux2_1
X_283_ _283_/Y _223_/Y _258_/A _282_/Y VPWR VGND sg13g2_o21ai_1
XFILLER_6_723 VPWR VGND sg13g2_decap_8
XFILLER_5_266 VPWR VGND sg13g2_fill_2
XFILLER_2_995 VPWR VGND sg13g2_decap_8
Xinput9 _618_/D ui_in[7] VPWR VGND sg13g2_buf_1
XFILLER_7_1000 VPWR VGND sg13g2_decap_8
XFILLER_49_476 VPWR VGND sg13g2_decap_8
XFILLER_45_693 VPWR VGND sg13g2_decap_8
X_619_ _619_/Q _622_/CLK _619_/D fanout73/X VPWR VGND sg13g2_dfrbpq_1
XFILLER_35_27 VPWR VGND sg13g2_fill_1
XFILLER_24_833 VPWR VGND sg13g2_decap_8
XFILLER_3_737 VPWR VGND sg13g2_decap_8
XFILLER_15_822 VPWR VGND sg13g2_decap_8
X_404_ _569_/D _568_/Q _569_/Q _405_/S VPWR VGND sg13g2_mux2_1
XFILLER_46_457 VPWR VGND sg13g2_decap_8
XFILLER_15_899 VPWR VGND sg13g2_fill_2
X_335_ _500_/D _499_/Q _500_/Q _350_/S VPWR VGND sg13g2_mux2_1
X_266_ _643_/D _266_/A _266_/B VPWR VGND sg13g2_nand2_1
XFILLER_2_792 VPWR VGND sg13g2_decap_8
XFILLER_6_597 VPWR VGND sg13g2_decap_8
XFILLER_49_273 VPWR VGND sg13g2_decap_8
XFILLER_12_847 VPWR VGND sg13g2_decap_8
XFILLER_7_317 VPWR VGND sg13g2_decap_8
XFILLER_2_2 VPWR VGND sg13g2_fill_1
XFILLER_3_534 VPWR VGND sg13g2_decap_8
XFILLER_47_777 VPWR VGND sg13g2_decap_8
XFILLER_47_700 VPWR VGND sg13g2_decap_8
Xinput12 _234_/A0 uio_in[2] VPWR VGND sg13g2_buf_1
X_318_ _483_/D _482_/Q _483_/Q _392_/S VPWR VGND sg13g2_mux2_1
X_249_ _249_/X _642_/Q _253_/B VPWR VGND sg13g2_and2_1
XFILLER_7_895 VPWR VGND sg13g2_decap_8
XFILLER_6_383 VPWR VGND sg13g2_fill_1
XFILLER_6_361 VPWR VGND sg13g2_decap_8
XFILLER_38_777 VPWR VGND sg13g2_decap_8
XFILLER_10_1008 VPWR VGND sg13g2_decap_8
XFILLER_0_559 VPWR VGND sg13g2_decap_8
XFILLER_29_777 VPWR VGND sg13g2_decap_8
XFILLER_44_769 VPWR VGND sg13g2_decap_8
XFILLER_7_169 VPWR VGND sg13g2_decap_8
XFILLER_3_342 VPWR VGND sg13g2_fill_2
XFILLER_4_876 VPWR VGND sg13g2_decap_8
XFILLER_47_574 VPWR VGND sg13g2_decap_8
XFILLER_43_791 VPWR VGND sg13g2_decap_8
Xclkbuf_leaf_6_clk _449_/B delaybuf_16_clk/X VPWR VGND sg13g2_buf_8
XFILLER_7_692 VPWR VGND sg13g2_decap_8
XFILLER_5_618 VPWR VGND sg13g2_decap_8
XFILLER_49_1015 VPWR VGND sg13g2_decap_8
XFILLER_0_345 VPWR VGND sg13g2_fill_1
XFILLER_1_824 VPWR VGND sg13g2_decap_8
XFILLER_1_1006 VPWR VGND sg13g2_decap_8
XFILLER_44_566 VPWR VGND sg13g2_decap_8
X_583_ _583_/Q _623_/CLK _583_/D fanout71/X VPWR VGND sg13g2_dfrbpq_1
X_652_ _652_/Q _660_/CLK _652_/D fanout80/X VPWR VGND sg13g2_dfrbpq_1
XFILLER_13_931 VPWR VGND sg13g2_decap_8
XFILLER_25_791 VPWR VGND sg13g2_decap_8
XFILLER_9_924 VPWR VGND sg13g2_decap_8
XFILLER_4_673 VPWR VGND sg13g2_decap_8
XFILLER_48_883 VPWR VGND sg13g2_decap_8
XFILLER_47_371 VPWR VGND sg13g2_decap_8
XFILLER_10_945 VPWR VGND sg13g2_decap_8
XFILLER_16_1003 VPWR VGND sg13g2_fill_1
Xclkbuf_0__017_ clkbuf_0__017_/X _256_/Y VPWR VGND sg13g2_buf_16
XFILLER_6_905 VPWR VGND sg13g2_decap_8
XFILLER_1_621 VPWR VGND sg13g2_decap_8
XFILLER_1_698 VPWR VGND sg13g2_decap_8
XFILLER_49_658 VPWR VGND sg13g2_decap_8
X_566_ _566_/Q _567_/CLK _566_/D fanout95/X VPWR VGND sg13g2_dfrbpq_1
X_635_ _635_/Q _449_/Y _635_/D fanout64/X VPWR VGND sg13g2_dfrbpq_1
X_497_ _497_/Q _498_/CLK _497_/D fanout89/X VPWR VGND sg13g2_dfrbpq_1
XFILLER_9_798 VPWR VGND sg13g2_decap_8
XFILLER_5_982 VPWR VGND sg13g2_decap_8
XFILLER_4_470 VPWR VGND sg13g2_fill_1
XFILLER_3_919 VPWR VGND sg13g2_decap_8
XFILLER_19_809 VPWR VGND sg13g2_decap_8
XFILLER_46_606 VPWR VGND sg13g2_decap_8
XFILLER_27_842 VPWR VGND sg13g2_decap_8
X_420_ _585_/D _584_/Q _585_/Q _436_/S VPWR VGND sg13g2_mux2_1
X_351_ _516_/D _515_/Q _516_/Q _366_/S VPWR VGND sg13g2_mux2_1
X_282_ _282_/Y _282_/A1 _279_/Y _281_/Y _282_/B2 VPWR VGND sg13g2_a22oi_1
XFILLER_6_702 VPWR VGND sg13g2_decap_8
XFILLER_5_212 VPWR VGND sg13g2_fill_2
XFILLER_2_974 VPWR VGND sg13g2_decap_8
XFILLER_6_779 VPWR VGND sg13g2_decap_8
XFILLER_1_495 VPWR VGND sg13g2_decap_8
XFILLER_49_455 VPWR VGND sg13g2_decap_8
XFILLER_45_672 VPWR VGND sg13g2_decap_8
X_549_ _549_/Q _562_/CLK _549_/D fanout93/X VPWR VGND sg13g2_dfrbpq_1
X_618_ _618_/Q _657_/CLK _618_/D fanout76/X VPWR VGND sg13g2_dfrbpq_1
XFILLER_24_812 VPWR VGND sg13g2_decap_8
XFILLER_3_716 VPWR VGND sg13g2_decap_8
XFILLER_46_436 VPWR VGND sg13g2_decap_8
XFILLER_15_801 VPWR VGND sg13g2_decap_8
XFILLER_15_878 VPWR VGND sg13g2_decap_8
XFILLER_30_826 VPWR VGND sg13g2_fill_2
X_403_ _568_/D _567_/Q _568_/Q _405_/S VPWR VGND sg13g2_mux2_1
X_334_ _499_/D _498_/Q _499_/Q _350_/S VPWR VGND sg13g2_mux2_1
X_265_ _644_/D _604_/Q _266_/A _264_/X VPWR VGND sg13g2_o21ai_1
XFILLER_6_576 VPWR VGND sg13g2_decap_8
XFILLER_2_10 VPWR VGND sg13g2_fill_1
XFILLER_2_771 VPWR VGND sg13g2_decap_8
XFILLER_12_826 VPWR VGND sg13g2_decap_8
XFILLER_43_406 VPWR VGND sg13g2_decap_8
XFILLER_8_819 VPWR VGND sg13g2_decap_8
XFILLER_3_513 VPWR VGND sg13g2_decap_8
XFILLER_47_756 VPWR VGND sg13g2_decap_8
Xinput13 _233_/A0 uio_in[3] VPWR VGND sg13g2_buf_1
X_317_ _482_/D _481_/Q _482_/Q _392_/S VPWR VGND sg13g2_mux2_1
X_248_ _248_/X _641_/Q _253_/B VPWR VGND sg13g2_and2_1
XFILLER_7_874 VPWR VGND sg13g2_decap_8
XFILLER_38_756 VPWR VGND sg13g2_decap_8
XFILLER_0_538 VPWR VGND sg13g2_decap_8
XFILLER_17_907 VPWR VGND sg13g2_decap_8
XFILLER_29_756 VPWR VGND sg13g2_decap_8
XFILLER_44_748 VPWR VGND sg13g2_decap_8
Xclkbuf_4_3_0_clk_regs clkbuf_4_3_0_clk_regs/X clkbuf_0_clk_regs/X VPWR VGND sg13g2_buf_8
XFILLER_3_310 VPWR VGND sg13g2_decap_4
XFILLER_4_855 VPWR VGND sg13g2_decap_8
XFILLER_16_962 VPWR VGND sg13g2_fill_2
XFILLER_43_770 VPWR VGND sg13g2_decap_8
XFILLER_47_553 VPWR VGND sg13g2_decap_8
XFILLER_7_671 VPWR VGND sg13g2_decap_8
XFILLER_34_770 VPWR VGND sg13g2_decap_8
XFILLER_34_781 VPWR VGND sg13g2_fill_2
XFILLER_41_729 VPWR VGND sg13g2_decap_8
XFILLER_0_302 VPWR VGND sg13g2_fill_2
XFILLER_1_803 VPWR VGND sg13g2_decap_8
XFILLER_13_910 VPWR VGND sg13g2_decap_8
XFILLER_25_770 VPWR VGND sg13g2_decap_8
X_582_ _609_/D _629_/CLK _582_/D fanout71/X VPWR VGND sg13g2_dfrbpq_1
X_651_ _651_/Q _658_/CLK _651_/D fanout78/X VPWR VGND sg13g2_dfrbpq_1
XFILLER_13_987 VPWR VGND sg13g2_decap_8
XFILLER_40_795 VPWR VGND sg13g2_decap_8
XFILLER_9_903 VPWR VGND sg13g2_decap_8
XFILLER_4_652 VPWR VGND sg13g2_decap_8
XFILLER_47_350 VPWR VGND sg13g2_decap_8
XFILLER_16_781 VPWR VGND sg13g2_decap_8
XFILLER_31_784 VPWR VGND sg13g2_decap_8
XFILLER_8_980 VPWR VGND sg13g2_decap_8
XFILLER_39_840 VPWR VGND sg13g2_decap_8
XFILLER_39_851 VPWR VGND sg13g2_fill_1
XFILLER_10_924 VPWR VGND sg13g2_decap_8
XFILLER_22_795 VPWR VGND sg13g2_decap_8
XFILLER_1_600 VPWR VGND sg13g2_decap_8
XFILLER_1_677 VPWR VGND sg13g2_decap_8
X_634_ _634_/Q _448_/Y _634_/D fanout70/X VPWR VGND sg13g2_dfrbpq_1
XFILLER_49_637 VPWR VGND sg13g2_decap_8
X_565_ _565_/Q _567_/CLK _565_/D fanout95/X VPWR VGND sg13g2_dfrbpq_1
X_496_ _496_/Q _498_/CLK _496_/D fanout89/X VPWR VGND sg13g2_dfrbpq_1
XFILLER_13_784 VPWR VGND sg13g2_decap_8
XFILLER_9_777 VPWR VGND sg13g2_decap_8
XFILLER_5_961 VPWR VGND sg13g2_decap_8
XFILLER_5_54 VPWR VGND sg13g2_fill_1
XFILLER_48_692 VPWR VGND sg13g2_decap_8
XFILLER_42_835 VPWR VGND sg13g2_decap_8
X_350_ _515_/D _514_/Q _515_/Q _350_/S VPWR VGND sg13g2_mux2_1
XFILLER_10_798 VPWR VGND sg13g2_decap_8
X_281_ _281_/Y _281_/A _279_/B VPWR VGND sg13g2_nor2b_1
XFILLER_6_758 VPWR VGND sg13g2_decap_8
XFILLER_1_474 VPWR VGND sg13g2_decap_8
XFILLER_2_953 VPWR VGND sg13g2_decap_8
XFILLER_45_651 VPWR VGND sg13g2_decap_8
X_617_ _617_/Q _657_/CLK _617_/D fanout76/X VPWR VGND sg13g2_dfrbpq_1
XFILLER_49_434 VPWR VGND sg13g2_decap_8
X_548_ _548_/Q _563_/CLK _548_/D fanout93/X VPWR VGND sg13g2_dfrbpq_1
X_479_ _479_/Q _556_/CLK _479_/D fanout91/X VPWR VGND sg13g2_dfrbpq_1
XFILLER_46_415 VPWR VGND sg13g2_decap_8
XFILLER_47_916 VPWR VGND sg13g2_decap_8
XFILLER_15_857 VPWR VGND sg13g2_decap_8
XFILLER_30_805 VPWR VGND sg13g2_decap_8
XFILLER_30_838 VPWR VGND sg13g2_decap_8
XFILLER_42_632 VPWR VGND sg13g2_decap_8
X_402_ _567_/D _566_/Q _567_/Q _405_/S VPWR VGND sg13g2_mux2_1
X_333_ _498_/D _497_/Q _498_/Q _350_/S VPWR VGND sg13g2_mux2_1
X_264_ _264_/X _618_/Q _266_/B VPWR VGND sg13g2_or2_1
XFILLER_6_555 VPWR VGND sg13g2_decap_8
XFILLER_2_750 VPWR VGND sg13g2_decap_8
XFILLER_21_805 VPWR VGND sg13g2_decap_8
XFILLER_12_805 VPWR VGND sg13g2_decap_8
XFILLER_3_569 VPWR VGND sg13g2_decap_8
XFILLER_4_1016 VPWR VGND sg13g2_decap_8
XFILLER_46_289 VPWR VGND sg13g2_decap_8
XFILLER_4_1027 VPWR VGND sg13g2_fill_2
XFILLER_47_735 VPWR VGND sg13g2_decap_8
XFILLER_11_882 VPWR VGND sg13g2_decap_8
X_316_ _481_/D _480_/Q _481_/Q _369_/S VPWR VGND sg13g2_mux2_1
X_247_ _247_/X _640_/Q _247_/B VPWR VGND sg13g2_and2_1
XFILLER_7_853 VPWR VGND sg13g2_decap_8
XFILLER_0_517 VPWR VGND sg13g2_decap_8
XFILLER_44_727 VPWR VGND sg13g2_decap_8
XFILLER_3_344 VPWR VGND sg13g2_fill_1
XFILLER_4_834 VPWR VGND sg13g2_decap_8
XFILLER_28_790 VPWR VGND sg13g2_decap_8
XFILLER_35_749 VPWR VGND sg13g2_decap_8
XFILLER_7_650 VPWR VGND sg13g2_decap_8
XFILLER_26_749 VPWR VGND sg13g2_decap_8
XFILLER_34_793 VPWR VGND sg13g2_decap_8
XFILLER_41_708 VPWR VGND sg13g2_decap_8
XFILLER_1_859 VPWR VGND sg13g2_decap_8
X_650_ _650_/Q _657_/CLK _650_/D fanout79/X VPWR VGND sg13g2_dfrbpq_1
XFILLER_49_819 VPWR VGND sg13g2_decap_8
XFILLER_48_329 VPWR VGND sg13g2_decap_8
XFILLER_17_749 VPWR VGND sg13g2_decap_8
X_581_ _608_/D _581_/CLK _581_/D fanout87/X VPWR VGND sg13g2_dfrbpq_1
XFILLER_13_966 VPWR VGND sg13g2_decap_8
XFILLER_40_774 VPWR VGND sg13g2_decap_8
XFILLER_9_959 VPWR VGND sg13g2_decap_8
XFILLER_4_631 VPWR VGND sg13g2_decap_8
XFILLER_0_881 VPWR VGND sg13g2_decap_8
XFILLER_31_763 VPWR VGND sg13g2_decap_8
XFILLER_43_590 VPWR VGND sg13g2_decap_8
XFILLER_10_903 VPWR VGND sg13g2_decap_8
XFILLER_22_774 VPWR VGND sg13g2_decap_8
XFILLER_1_656 VPWR VGND sg13g2_decap_8
XFILLER_49_616 VPWR VGND sg13g2_decap_8
XFILLER_44_332 VPWR VGND sg13g2_fill_2
XFILLER_45_833 VPWR VGND sg13g2_decap_8
X_633_ _633_/Q _447_/Y _633_/D fanout69/X VPWR VGND sg13g2_dfrbpq_1
XFILLER_13_763 VPWR VGND sg13g2_decap_8
XFILLER_44_387 VPWR VGND sg13g2_decap_8
X_564_ _564_/Q _567_/CLK _564_/D fanout95/X VPWR VGND sg13g2_dfrbpq_1
X_495_ _495_/Q _498_/CLK _495_/D fanout89/X VPWR VGND sg13g2_dfrbpq_1
XFILLER_9_756 VPWR VGND sg13g2_decap_8
XFILLER_5_940 VPWR VGND sg13g2_decap_8
XFILLER_36_822 VPWR VGND sg13g2_decap_8
XFILLER_48_671 VPWR VGND sg13g2_decap_8
XFILLER_42_814 VPWR VGND sg13g2_decap_8
X_280_ _280_/X _280_/A0 _280_/A1 _441_/A _649_/Q _279_/B _281_/A VPWR VGND sg13g2_mux4_1
XFILLER_10_777 VPWR VGND sg13g2_decap_8
XFILLER_6_737 VPWR VGND sg13g2_decap_8
XFILLER_1_453 VPWR VGND sg13g2_decap_8
XFILLER_2_932 VPWR VGND sg13g2_decap_8
XFILLER_7_1014 VPWR VGND sg13g2_decap_8
XFILLER_49_413 VPWR VGND sg13g2_decap_8
XFILLER_45_630 VPWR VGND sg13g2_decap_8
X_547_ _547_/Q _563_/CLK _547_/D fanout93/X VPWR VGND sg13g2_dfrbpq_1
X_616_ _616_/Q _630_/CLK _616_/D fanout67/X VPWR VGND sg13g2_dfrbpq_1
X_478_ _478_/Q _556_/CLK _478_/D fanout91/X VPWR VGND sg13g2_dfrbpq_1
XFILLER_48_490 VPWR VGND sg13g2_decap_8
XFILLER_24_847 VPWR VGND sg13g2_decap_4
XFILLER_13_1008 VPWR VGND sg13g2_decap_8
Xclkbuf_0_clk_regs clkbuf_0_clk_regs/X clkbuf_regs_0_clk/X VPWR VGND sg13g2_buf_16
XFILLER_2_228 VPWR VGND sg13g2_decap_4
XFILLER_15_836 VPWR VGND sg13g2_decap_8
XFILLER_42_611 VPWR VGND sg13g2_decap_8
X_401_ _566_/D _565_/Q _566_/Q _405_/S VPWR VGND sg13g2_mux2_1
X_332_ _497_/D _496_/Q _497_/Q _332_/S VPWR VGND sg13g2_mux2_1
X_263_ _645_/D _222_/Y _266_/A _262_/Y VPWR VGND sg13g2_o21ai_1
XFILLER_6_534 VPWR VGND sg13g2_decap_8
XFILLER_2_45 VPWR VGND sg13g2_fill_1
XFILLER_49_287 VPWR VGND sg13g2_decap_8
XFILLER_3_548 VPWR VGND sg13g2_decap_8
Xdelaybuf_1_clk u_delay_line/clk _440_/B VPWR VGND sg13g2_buf_16
XFILLER_47_714 VPWR VGND sg13g2_decap_8
XFILLER_46_268 VPWR VGND sg13g2_decap_8
XFILLER_11_861 VPWR VGND sg13g2_decap_8
X_315_ _480_/D _479_/Q _480_/Q _369_/S VPWR VGND sg13g2_mux2_1
X_246_ _246_/X _639_/Q _247_/B VPWR VGND sg13g2_and2_1
XFILLER_7_832 VPWR VGND sg13g2_decap_8
XFILLER_6_375 VPWR VGND sg13g2_decap_4
XFILLER_37_791 VPWR VGND sg13g2_decap_8
XFILLER_44_706 VPWR VGND sg13g2_decap_8
XFILLER_3_301 VPWR VGND sg13g2_fill_1
XFILLER_4_813 VPWR VGND sg13g2_decap_8
XFILLER_47_588 VPWR VGND sg13g2_decap_8
XFILLER_16_964 VPWR VGND sg13g2_fill_1
X_229_ _467_/D _234_/A0 _467_/Q _231_/S VPWR VGND sg13g2_mux2_1
XFILLER_1_838 VPWR VGND sg13g2_decap_8
X_580_ _580_/Q _621_/CLK _580_/D fanout86/X VPWR VGND sg13g2_dfrbpq_1
XFILLER_48_308 VPWR VGND sg13g2_decap_8
XFILLER_13_945 VPWR VGND sg13g2_decap_8
XFILLER_9_938 VPWR VGND sg13g2_decap_8
XFILLER_4_610 VPWR VGND sg13g2_decap_8
XFILLER_0_860 VPWR VGND sg13g2_decap_8
XFILLER_4_687 VPWR VGND sg13g2_decap_8
XFILLER_48_897 VPWR VGND sg13g2_decap_4
XFILLER_48_864 VPWR VGND sg13g2_fill_1
XFILLER_48_853 VPWR VGND sg13g2_decap_8
XFILLER_47_385 VPWR VGND sg13g2_decap_8
XFILLER_22_753 VPWR VGND sg13g2_fill_2
XFILLER_10_959 VPWR VGND sg13g2_decap_8
XFILLER_6_919 VPWR VGND sg13g2_decap_8
XFILLER_1_635 VPWR VGND sg13g2_decap_8
XFILLER_0_189 VPWR VGND sg13g2_fill_1
XFILLER_44_366 VPWR VGND sg13g2_decap_8
XFILLER_45_812 VPWR VGND sg13g2_decap_8
X_563_ _563_/Q _563_/CLK _563_/D fanout94/X VPWR VGND sg13g2_dfrbpq_1
X_632_ _632_/Q _446_/Y _632_/D fanout69/X VPWR VGND sg13g2_dfrbpq_1
XFILLER_48_149 VPWR VGND sg13g2_fill_1
X_494_ _494_/Q _551_/CLK _494_/D fanout97/X VPWR VGND sg13g2_dfrbpq_1
XFILLER_5_996 VPWR VGND sg13g2_decap_8
XFILLER_36_801 VPWR VGND sg13g2_decap_8
XFILLER_48_650 VPWR VGND sg13g2_decap_8
XFILLER_27_812 VPWR VGND sg13g2_decap_8
XFILLER_27_823 VPWR VGND sg13g2_fill_2
XFILLER_10_756 VPWR VGND sg13g2_decap_8
XFILLER_2_911 VPWR VGND sg13g2_decap_8
XFILLER_6_716 VPWR VGND sg13g2_decap_8
XFILLER_18_812 VPWR VGND sg13g2_decap_8
XFILLER_1_432 VPWR VGND sg13g2_decap_8
XFILLER_2_988 VPWR VGND sg13g2_decap_8
XFILLER_49_469 VPWR VGND sg13g2_decap_8
XFILLER_18_845 VPWR VGND sg13g2_decap_8
XFILLER_45_686 VPWR VGND sg13g2_decap_8
X_546_ _546_/Q _563_/CLK _546_/D fanout93/X VPWR VGND sg13g2_dfrbpq_1
X_615_ _615_/Q _615_/CLK _615_/D fanout67/X VPWR VGND sg13g2_dfrbpq_1
Xu_multimode_dll VPWR VGND _514_/Q _280_/A0 _496_/Q _497_/Q _498_/Q _499_/Q _500_/Q
+ _282_/A1 _501_/Q _502_/Q _503_/Q _504_/Q _505_/Q _284_/A1 _506_/Q _507_/Q _508_/Q
+ _509_/Q _510_/Q _515_/Q ena _516_/Q _526_/Q _527_/Q _528_/Q _529_/Q _530_/Q _531_/Q
+ _532_/Q _533_/Q _534_/Q _535_/Q _517_/Q _536_/Q _537_/Q _538_/Q _539_/Q _540_/Q
+ _541_/Q _518_/Q _519_/Q _520_/Q _521_/Q _522_/Q _523_/Q _524_/Q _525_/Q _481_/Q
+ _482_/Q _483_/Q _484_/Q _485_/Q _486_/Q _487_/Q _488_/Q _489_/Q _490_/Q _491_/Q
+ _492_/Q _493_/Q _494_/Q _495_/Q _476_/Q _477_/Q _478_/Q _479_/Q _480_/Q _511_/Q
+ _512_/Q _513_/Q delaybuf_0_clk/X _288_/A1 fanout89/X _286_/A1 multimode_dll
X_477_ _477_/Q _571_/CLK _477_/D fanout91/X VPWR VGND sg13g2_dfrbpq_1
XFILLER_5_793 VPWR VGND sg13g2_decap_8
XFILLER_24_826 VPWR VGND sg13g2_decap_8
XFILLER_2_207 VPWR VGND sg13g2_fill_2
XFILLER_15_815 VPWR VGND sg13g2_decap_8
X_400_ _565_/D _564_/Q _565_/Q _405_/S VPWR VGND sg13g2_mux2_1
X_331_ _496_/D _495_/Q _496_/Q _332_/S VPWR VGND sg13g2_mux2_1
X_262_ _262_/Y _275_/S _617_/Q _618_/Q VPWR VGND sg13g2_nand3_1
XFILLER_2_785 VPWR VGND sg13g2_decap_8
XFILLER_49_266 VPWR VGND sg13g2_decap_8
X_529_ _529_/Q _604_/CLK _529_/D fanout70/X VPWR VGND sg13g2_dfrbpq_1
XFILLER_5_590 VPWR VGND sg13g2_decap_8
XFILLER_49_0 VPWR VGND sg13g2_fill_1
XFILLER_3_527 VPWR VGND sg13g2_decap_8
XFILLER_36_63 VPWR VGND sg13g2_fill_1
X_314_ _479_/D _478_/Q _479_/Q _369_/S VPWR VGND sg13g2_mux2_1
XFILLER_11_840 VPWR VGND sg13g2_decap_8
X_245_ _245_/X _638_/Q _247_/B VPWR VGND sg13g2_and2_1
XFILLER_7_888 VPWR VGND sg13g2_decap_8
XFILLER_7_811 VPWR VGND sg13g2_decap_8
XFILLER_6_354 VPWR VGND sg13g2_decap_8
XFILLER_2_582 VPWR VGND sg13g2_decap_8
XFILLER_37_770 VPWR VGND sg13g2_decap_8
XFILLER_4_869 VPWR VGND sg13g2_decap_8
XFILLER_47_567 VPWR VGND sg13g2_decap_8
XFILLER_43_784 VPWR VGND sg13g2_decap_8
X_228_ _468_/D _233_/A0 _656_/D _231_/S VPWR VGND sg13g2_mux2_1
XFILLER_7_685 VPWR VGND sg13g2_decap_8
XFILLER_6_173 VPWR VGND sg13g2_decap_4
XFILLER_3_891 VPWR VGND sg13g2_decap_8
XFILLER_19_781 VPWR VGND sg13g2_decap_8
XFILLER_1_817 VPWR VGND sg13g2_decap_8
XFILLER_49_1008 VPWR VGND sg13g2_decap_8
XFILLER_13_924 VPWR VGND sg13g2_decap_8
XFILLER_25_784 VPWR VGND sg13g2_decap_8
XFILLER_44_559 VPWR VGND sg13g2_decap_8
XFILLER_9_917 VPWR VGND sg13g2_decap_8
XFILLER_4_666 VPWR VGND sg13g2_decap_8
XFILLER_48_832 VPWR VGND sg13g2_decap_8
XFILLER_16_795 VPWR VGND sg13g2_decap_8
XFILLER_48_876 VPWR VGND sg13g2_decap_8
XFILLER_47_364 VPWR VGND sg13g2_decap_8
XFILLER_31_798 VPWR VGND sg13g2_decap_8
Xclkbuf_4_2_0_clk_regs clkbuf_4_2_0_clk_regs/X clkbuf_0_clk_regs/X VPWR VGND sg13g2_buf_8
XFILLER_8_994 VPWR VGND sg13g2_decap_8
XFILLER_0_1021 VPWR VGND sg13g2_decap_8
XFILLER_22_765 VPWR VGND sg13g2_decap_4
XFILLER_10_938 VPWR VGND sg13g2_decap_8
XFILLER_1_614 VPWR VGND sg13g2_decap_8
X_562_ _562_/Q _562_/CLK _562_/D fanout93/X VPWR VGND sg13g2_dfrbpq_1
X_631_ _631_/Q _445_/Y _631_/D fanout72/X VPWR VGND sg13g2_dfrbpq_1
X_493_ _493_/Q _551_/CLK _493_/D fanout97/X VPWR VGND sg13g2_dfrbpq_1
XFILLER_13_798 VPWR VGND sg13g2_decap_8
XFILLER_5_975 VPWR VGND sg13g2_decap_8
XFILLER_8_791 VPWR VGND sg13g2_decap_8
XFILLER_27_835 VPWR VGND sg13g2_decap_8
XFILLER_42_849 VPWR VGND sg13g2_fill_2
XFILLER_2_967 VPWR VGND sg13g2_decap_8
XFILLER_5_205 VPWR VGND sg13g2_decap_8
XFILLER_1_488 VPWR VGND sg13g2_decap_8
XFILLER_49_448 VPWR VGND sg13g2_decap_8
XFILLER_45_665 VPWR VGND sg13g2_decap_8
X_545_ _545_/Q _556_/CLK _545_/D fanout96/X VPWR VGND sg13g2_dfrbpq_1
X_614_ _614_/Q _615_/CLK _614_/D fanout66/X VPWR VGND sg13g2_dfrbpq_1
X_476_ _476_/Q _649_/CLK _476_/D fanout80/X VPWR VGND sg13g2_dfrbpq_1
Xdelaybuf_20_clk delaybuf_21_clk/A delaybuf_20_clk/A VPWR VGND sg13g2_buf_16
XFILLER_5_772 VPWR VGND sg13g2_decap_8
XFILLER_24_805 VPWR VGND sg13g2_decap_8
XFILLER_3_709 VPWR VGND sg13g2_decap_8
XFILLER_46_429 VPWR VGND sg13g2_decap_8
Xdelaybuf_11_clk delaybuf_12_clk/A delaybuf_11_clk/A VPWR VGND sg13g2_buf_16
XFILLER_30_819 VPWR VGND sg13g2_decap_8
XFILLER_42_646 VPWR VGND sg13g2_fill_2
X_330_ _495_/D _494_/Q _495_/Q _332_/S VPWR VGND sg13g2_mux2_1
X_261_ _266_/B _275_/S _617_/Q VPWR VGND sg13g2_nand2_1
XFILLER_6_569 VPWR VGND sg13g2_decap_8
XFILLER_2_764 VPWR VGND sg13g2_decap_8
XFILLER_45_462 VPWR VGND sg13g2_decap_8
XFILLER_45_473 VPWR VGND sg13g2_fill_1
XFILLER_14_882 VPWR VGND sg13g2_decap_8
XFILLER_21_819 VPWR VGND sg13g2_decap_4
XFILLER_45_484 VPWR VGND sg13g2_fill_1
X_528_ _528_/Q _656_/CLK _528_/D fanout70/X VPWR VGND sg13g2_dfrbpq_1
X_459_ _459_/Y _460_/A _459_/B VPWR VGND sg13g2_xnor2_1
XFILLER_12_819 VPWR VGND sg13g2_decap_8
XFILLER_20_830 VPWR VGND sg13g2_fill_1
XFILLER_20_841 VPWR VGND sg13g2_decap_8
XFILLER_3_506 VPWR VGND sg13g2_decap_8
Xclkbuf_4_15_0_clk_regs clkbuf_4_15_0_clk_regs/X clkbuf_0_clk_regs/X VPWR VGND sg13g2_buf_8
XFILLER_46_237 VPWR VGND sg13g2_fill_1
XFILLER_47_749 VPWR VGND sg13g2_decap_8
X_313_ _478_/D _477_/Q _478_/Q _369_/S VPWR VGND sg13g2_mux2_1
X_244_ _244_/X _637_/Q _247_/B VPWR VGND sg13g2_and2_1
XFILLER_11_896 VPWR VGND sg13g2_decap_8
XFILLER_7_867 VPWR VGND sg13g2_decap_8
XFILLER_6_388 VPWR VGND sg13g2_fill_1
XFILLER_2_561 VPWR VGND sg13g2_decap_8
XFILLER_38_749 VPWR VGND sg13g2_decap_8
XFILLER_45_292 VPWR VGND sg13g2_decap_8
XFILLER_46_793 VPWR VGND sg13g2_decap_8
XFILLER_29_749 VPWR VGND sg13g2_decap_8
XFILLER_3_314 VPWR VGND sg13g2_fill_1
XFILLER_7_108 VPWR VGND sg13g2_fill_1
XFILLER_4_848 VPWR VGND sg13g2_decap_8
XFILLER_16_955 VPWR VGND sg13g2_decap_8
XFILLER_43_763 VPWR VGND sg13g2_decap_8
XFILLER_47_546 VPWR VGND sg13g2_decap_8
XFILLER_16_999 VPWR VGND sg13g2_decap_4
X_227_ _231_/S _648_/Q _647_/Q VPWR VGND sg13g2_nand2_1
XFILLER_8_13 VPWR VGND sg13g2_fill_1
XFILLER_3_870 VPWR VGND sg13g2_decap_8
XFILLER_7_664 VPWR VGND sg13g2_decap_8
XFILLER_34_763 VPWR VGND sg13g2_decap_8
XFILLER_13_903 VPWR VGND sg13g2_decap_8
XFILLER_25_763 VPWR VGND sg13g2_decap_8
XFILLER_40_788 VPWR VGND sg13g2_decap_8
XFILLER_4_645 VPWR VGND sg13g2_decap_8
XFILLER_0_895 VPWR VGND sg13g2_decap_8
XFILLER_48_811 VPWR VGND sg13g2_decap_8
XFILLER_47_343 VPWR VGND sg13g2_decap_8
XFILLER_16_774 VPWR VGND sg13g2_decap_8
XFILLER_12_980 VPWR VGND sg13g2_decap_8
XFILLER_31_777 VPWR VGND sg13g2_decap_8
XFILLER_8_973 VPWR VGND sg13g2_decap_8
XFILLER_7_483 VPWR VGND sg13g2_fill_2
XFILLER_24_0 VPWR VGND sg13g2_fill_2
XFILLER_0_1000 VPWR VGND sg13g2_decap_8
XFILLER_39_833 VPWR VGND sg13g2_decap_8
XFILLER_10_917 VPWR VGND sg13g2_decap_8
XFILLER_22_788 VPWR VGND sg13g2_decap_8
XFILLER_0_125 VPWR VGND sg13g2_fill_1
X_630_ _630_/Q _630_/CLK _630_/D fanout67/X VPWR VGND sg13g2_dfrbpq_1
Xclkbuf_1_1__f_clk clkload0/A delaybuf_22_clk/X VPWR VGND sg13g2_buf_16
XFILLER_45_847 VPWR VGND sg13g2_decap_4
X_561_ _561_/Q _563_/CLK _561_/D fanout93/X VPWR VGND sg13g2_dfrbpq_1
X_492_ _492_/Q _498_/CLK _492_/D fanout89/X VPWR VGND sg13g2_dfrbpq_1
XFILLER_13_777 VPWR VGND sg13g2_decap_8
XFILLER_5_954 VPWR VGND sg13g2_decap_8
XFILLER_4_442 VPWR VGND sg13g2_decap_8
XFILLER_0_692 VPWR VGND sg13g2_decap_8
XFILLER_48_685 VPWR VGND sg13g2_decap_8
XFILLER_47_184 VPWR VGND sg13g2_fill_1
XFILLER_47_173 VPWR VGND sg13g2_fill_1
XFILLER_8_770 VPWR VGND sg13g2_decap_8
XFILLER_42_828 VPWR VGND sg13g2_decap_8
XFILLER_1_467 VPWR VGND sg13g2_decap_8
XFILLER_2_946 VPWR VGND sg13g2_decap_8
XFILLER_39_31 VPWR VGND sg13g2_fill_2
XFILLER_45_644 VPWR VGND sg13g2_decap_8
X_613_ _613_/Q _615_/CLK _613_/D fanout64/X VPWR VGND sg13g2_dfrbpq_1
XFILLER_7_1028 VPWR VGND sg13g2_fill_1
XFILLER_49_427 VPWR VGND sg13g2_decap_8
X_544_ _544_/Q _557_/CLK _544_/D fanout96/X VPWR VGND sg13g2_dfrbpq_1
X_475_ _475_/Q _660_/CLK _475_/D fanout78/X VPWR VGND sg13g2_dfrbpq_1
XFILLER_5_751 VPWR VGND sg13g2_decap_8
XFILLER_46_408 VPWR VGND sg13g2_decap_8
XFILLER_47_909 VPWR VGND sg13g2_decap_8
XFILLER_42_625 VPWR VGND sg13g2_decap_8
X_260_ _266_/A _647_/D _603_/Q VPWR VGND sg13g2_nand2_1
Xdelaybuf_4_clk delaybuf_5_clk/A delaybuf_4_clk/A VPWR VGND sg13g2_buf_16
XFILLER_6_548 VPWR VGND sg13g2_decap_8
XFILLER_1_253 VPWR VGND sg13g2_decap_8
XFILLER_2_743 VPWR VGND sg13g2_decap_8
XFILLER_45_441 VPWR VGND sg13g2_decap_8
X_527_ _527_/Q _611_/CLK _527_/D fanout70/X VPWR VGND sg13g2_dfrbpq_1
XFILLER_14_861 VPWR VGND sg13g2_decap_8
XFILLER_41_680 VPWR VGND sg13g2_decap_8
X_458_ _458_/Y _460_/A _458_/B VPWR VGND sg13g2_xnor2_1
X_389_ _554_/D _553_/Q _554_/Q _391_/S VPWR VGND sg13g2_mux2_1
XFILLER_12_1022 VPWR VGND sg13g2_decap_8
Xclkbuf_1_0__f__017__regs _461_/CLK clkbuf_0__017__regs/X VPWR VGND sg13g2_buf_16
XFILLER_49_791 VPWR VGND sg13g2_decap_8
XFILLER_2_8 VPWR VGND sg13g2_fill_2
XFILLER_46_249 VPWR VGND sg13g2_decap_4
XFILLER_4_1009 VPWR VGND sg13g2_decap_8
XFILLER_47_728 VPWR VGND sg13g2_decap_8
XFILLER_11_875 VPWR VGND sg13g2_decap_8
XFILLER_42_444 VPWR VGND sg13g2_fill_2
X_312_ _477_/D _476_/Q _477_/Q _369_/S VPWR VGND sg13g2_mux2_1
X_243_ _243_/X _636_/Q _247_/B VPWR VGND sg13g2_and2_1
XFILLER_2_540 VPWR VGND sg13g2_decap_8
XFILLER_7_846 VPWR VGND sg13g2_decap_8
XFILLER_45_271 VPWR VGND sg13g2_decap_8
XFILLER_46_772 VPWR VGND sg13g2_decap_8
XFILLER_4_827 VPWR VGND sg13g2_decap_8
XFILLER_28_783 VPWR VGND sg13g2_decap_8
XFILLER_43_742 VPWR VGND sg13g2_decap_8
X_226_ _226_/Y _653_/Q VPWR VGND sg13g2_inv_1
XFILLER_7_643 VPWR VGND sg13g2_decap_8
XFILLER_13_959 VPWR VGND sg13g2_decap_8
XFILLER_4_624 VPWR VGND sg13g2_decap_8
XFILLER_0_874 VPWR VGND sg13g2_decap_8
Xclkbuf_2_1__f_clk_delayed _441_/A clkbuf_0_clk_delayed/X VPWR VGND sg13g2_buf_16
XFILLER_47_322 VPWR VGND sg13g2_decap_8
XFILLER_31_756 VPWR VGND sg13g2_decap_8
XFILLER_43_583 VPWR VGND sg13g2_decap_8
XFILLER_47_399 VPWR VGND sg13g2_decap_8
XFILLER_8_952 VPWR VGND sg13g2_decap_8
XFILLER_7_462 VPWR VGND sg13g2_decap_8
XFILLER_39_812 VPWR VGND sg13g2_decap_8
XFILLER_17_0 VPWR VGND sg13g2_fill_1
XFILLER_1_649 VPWR VGND sg13g2_decap_8
XFILLER_45_826 VPWR VGND sg13g2_decap_8
X_560_ _560_/Q _562_/CLK _560_/D fanout94/X VPWR VGND sg13g2_dfrbpq_1
XFILLER_49_609 VPWR VGND sg13g2_decap_8
XFILLER_13_756 VPWR VGND sg13g2_decap_8
XFILLER_44_325 VPWR VGND sg13g2_decap_8
XFILLER_44_98 VPWR VGND sg13g2_fill_2
X_491_ _491_/Q _515_/CLK _491_/D fanout89/X VPWR VGND sg13g2_dfrbpq_1
XFILLER_9_749 VPWR VGND sg13g2_decap_8
XFILLER_5_933 VPWR VGND sg13g2_decap_8
XFILLER_4_421 VPWR VGND sg13g2_decap_8
XFILLER_0_671 VPWR VGND sg13g2_decap_8
XFILLER_4_498 VPWR VGND sg13g2_decap_8
XFILLER_36_815 VPWR VGND sg13g2_decap_8
XFILLER_36_848 VPWR VGND sg13g2_decap_4
XFILLER_48_664 VPWR VGND sg13g2_decap_8
XFILLER_42_807 VPWR VGND sg13g2_decap_8
XFILLER_1_446 VPWR VGND sg13g2_decap_8
XFILLER_2_925 VPWR VGND sg13g2_decap_8
XFILLER_7_1007 VPWR VGND sg13g2_decap_8
XFILLER_49_406 VPWR VGND sg13g2_decap_8
XFILLER_18_826 VPWR VGND sg13g2_fill_2
XFILLER_45_623 VPWR VGND sg13g2_decap_8
X_543_ _543_/Q _557_/CLK _543_/D fanout96/X VPWR VGND sg13g2_dfrbpq_1
X_612_ _612_/Q _626_/CLK _612_/D fanout65/X VPWR VGND sg13g2_dfrbpq_1
X_474_ _474_/Q _658_/CLK _474_/D fanout78/X VPWR VGND sg13g2_dfrbpq_1
XFILLER_5_730 VPWR VGND sg13g2_decap_8
XFILLER_49_973 VPWR VGND sg13g2_fill_1
XFILLER_48_483 VPWR VGND sg13g2_decap_8
XFILLER_42_604 VPWR VGND sg13g2_decap_8
XFILLER_15_829 VPWR VGND sg13g2_decap_8
XFILLER_42_648 VPWR VGND sg13g2_fill_1
XFILLER_2_722 VPWR VGND sg13g2_decap_8
XFILLER_2_38 VPWR VGND sg13g2_fill_2
XFILLER_2_799 VPWR VGND sg13g2_decap_8
XFILLER_14_840 VPWR VGND sg13g2_decap_8
XFILLER_45_420 VPWR VGND sg13g2_decap_8
X_526_ _526_/Q _610_/CLK _526_/D fanout69/X VPWR VGND sg13g2_dfrbpq_1
XFILLER_12_1001 VPWR VGND sg13g2_decap_8
X_457_ _457_/Y _460_/A _460_/B VPWR VGND sg13g2_xnor2_1
X_388_ _553_/D _552_/Q _553_/Q _391_/S VPWR VGND sg13g2_mux2_1
XFILLER_49_770 VPWR VGND sg13g2_decap_8
XFILLER_48_280 VPWR VGND sg13g2_decap_8
XFILLER_47_707 VPWR VGND sg13g2_decap_8
XFILLER_11_854 VPWR VGND sg13g2_decap_8
X_311_ _476_/D _476_/Q input3/X _311_/S VPWR VGND sg13g2_mux2_1
X_242_ _242_/X _635_/Q _247_/B VPWR VGND sg13g2_and2_1
XFILLER_7_825 VPWR VGND sg13g2_decap_8
XFILLER_6_368 VPWR VGND sg13g2_decap_8
XFILLER_2_596 VPWR VGND sg13g2_decap_8
XFILLER_46_751 VPWR VGND sg13g2_decap_8
X_509_ _509_/Q _606_/CLK _509_/D fanout85/X VPWR VGND sg13g2_dfrbpq_1
XFILLER_6_891 VPWR VGND sg13g2_decap_8
XFILLER_37_784 VPWR VGND sg13g2_decap_8
XFILLER_3_1010 VPWR VGND sg13g2_decap_8
XFILLER_4_806 VPWR VGND sg13g2_decap_8
XFILLER_28_762 VPWR VGND sg13g2_decap_8
XFILLER_43_721 VPWR VGND sg13g2_decap_8
XFILLER_43_798 VPWR VGND sg13g2_decap_8
X_225_ _225_/Y _652_/Q VPWR VGND sg13g2_inv_1
XFILLER_7_699 VPWR VGND sg13g2_decap_8
XFILLER_7_622 VPWR VGND sg13g2_decap_8
XFILLER_19_795 VPWR VGND sg13g2_decap_8
XFILLER_46_592 VPWR VGND sg13g2_decap_8
XFILLER_13_938 VPWR VGND sg13g2_decap_8
XFILLER_25_798 VPWR VGND sg13g2_decap_8
XFILLER_4_603 VPWR VGND sg13g2_decap_8
XFILLER_0_853 VPWR VGND sg13g2_decap_8
XFILLER_48_846 VPWR VGND sg13g2_decap_8
XFILLER_47_378 VPWR VGND sg13g2_decap_8
XFILLER_47_301 VPWR VGND sg13g2_decap_8
XFILLER_43_562 VPWR VGND sg13g2_decap_8
XFILLER_8_931 VPWR VGND sg13g2_decap_8
XFILLER_7_496 VPWR VGND sg13g2_decap_8
XFILLER_7_485 VPWR VGND sg13g2_fill_1
XFILLER_48_1022 VPWR VGND sg13g2_decap_8
XFILLER_1_628 VPWR VGND sg13g2_decap_8
XFILLER_45_805 VPWR VGND sg13g2_decap_8
XFILLER_44_359 VPWR VGND sg13g2_decap_8
X_490_ _490_/Q _515_/CLK _490_/D fanout88/X VPWR VGND sg13g2_dfrbpq_1
XFILLER_5_989 VPWR VGND sg13g2_decap_8
XFILLER_5_912 VPWR VGND sg13g2_decap_8
XFILLER_0_650 VPWR VGND sg13g2_decap_8
XFILLER_48_643 VPWR VGND sg13g2_decap_8
XFILLER_43_392 VPWR VGND sg13g2_decap_8
Xdelaybuf_23_clk delaybuf_24_clk/A clk VPWR VGND sg13g2_buf_16
XFILLER_7_282 VPWR VGND sg13g2_decap_8
XFILLER_7_271 VPWR VGND sg13g2_fill_1
XFILLER_27_805 VPWR VGND sg13g2_decap_8
XFILLER_27_849 VPWR VGND sg13g2_fill_2
XFILLER_10_749 VPWR VGND sg13g2_decap_8
XFILLER_2_904 VPWR VGND sg13g2_decap_8
XFILLER_6_709 VPWR VGND sg13g2_decap_8
Xclkbuf_4_1_0_clk_regs clkbuf_4_1_0_clk_regs/X clkbuf_0_clk_regs/X VPWR VGND sg13g2_buf_8
Xdelaybuf_14_clk delaybuf_15_clk/A delaybuf_14_clk/A VPWR VGND sg13g2_buf_16
XFILLER_18_805 VPWR VGND sg13g2_decap_8
XFILLER_18_838 VPWR VGND sg13g2_decap_8
XFILLER_45_602 VPWR VGND sg13g2_decap_8
XFILLER_45_679 VPWR VGND sg13g2_decap_8
X_542_ _542_/Q _551_/CLK _542_/D fanout94/X VPWR VGND sg13g2_dfrbpq_1
X_611_ _611_/Q _611_/CLK _611_/D fanout65/X VPWR VGND sg13g2_dfrbpq_1
X_473_ _473_/Q _658_/CLK _473_/D fanout78/X VPWR VGND sg13g2_dfrbpq_1
XFILLER_41_841 VPWR VGND sg13g2_decap_8
XFILLER_5_786 VPWR VGND sg13g2_decap_8
XFILLER_1_992 VPWR VGND sg13g2_decap_8
XFILLER_48_462 VPWR VGND sg13g2_decap_8
XFILLER_24_819 VPWR VGND sg13g2_decap_8
XFILLER_6_70 VPWR VGND sg13g2_fill_1
XFILLER_15_808 VPWR VGND sg13g2_decap_8
XFILLER_23_841 VPWR VGND sg13g2_decap_8
XFILLER_2_701 VPWR VGND sg13g2_decap_8
XFILLER_2_778 VPWR VGND sg13g2_decap_8
X_525_ _525_/Q _611_/CLK _525_/D fanout69/X VPWR VGND sg13g2_dfrbpq_1
X_456_ _456_/Y _456_/A _456_/B VPWR VGND sg13g2_xnor2_1
XFILLER_14_896 VPWR VGND sg13g2_decap_8
X_387_ _552_/D _551_/Q _552_/Q _405_/S VPWR VGND sg13g2_mux2_1
XFILLER_5_583 VPWR VGND sg13g2_decap_8
X_310_ _475_/D _475_/Q _310_/B VPWR VGND sg13g2_xnor2_1
XFILLER_11_833 VPWR VGND sg13g2_decap_8
X_241_ _241_/X _656_/Q _255_/B VPWR VGND sg13g2_and2_1
XFILLER_7_804 VPWR VGND sg13g2_decap_8
XFILLER_2_575 VPWR VGND sg13g2_decap_8
XFILLER_46_730 VPWR VGND sg13g2_decap_8
X_508_ _508_/Q _606_/CLK _508_/D fanout73/X VPWR VGND sg13g2_dfrbpq_1
X_439_ _439_/Y _460_/A _440_/B VPWR VGND sg13g2_xnor2_1
XFILLER_6_870 VPWR VGND sg13g2_decap_8
XFILLER_37_763 VPWR VGND sg13g2_decap_8
XFILLER_43_777 VPWR VGND sg13g2_decap_8
X_224_ _224_/Y _651_/Q VPWR VGND sg13g2_inv_1
XFILLER_7_678 VPWR VGND sg13g2_decap_8
XFILLER_7_601 VPWR VGND sg13g2_decap_8
XFILLER_6_166 VPWR VGND sg13g2_decap_8
XFILLER_3_884 VPWR VGND sg13g2_decap_8
XFILLER_19_774 VPWR VGND sg13g2_decap_8
XFILLER_34_777 VPWR VGND sg13g2_decap_4
Xclkbuf_4_14_0_clk_regs clkbuf_4_14_0_clk_regs/X clkbuf_0_clk_regs/X VPWR VGND sg13g2_buf_8
XFILLER_46_571 VPWR VGND sg13g2_decap_8
XFILLER_13_917 VPWR VGND sg13g2_decap_8
XFILLER_25_777 VPWR VGND sg13g2_decap_8
XFILLER_3_125 VPWR VGND sg13g2_fill_2
XFILLER_4_659 VPWR VGND sg13g2_decap_8
XFILLER_0_832 VPWR VGND sg13g2_decap_8
XFILLER_3_158 VPWR VGND sg13g2_fill_2
XFILLER_48_825 VPWR VGND sg13g2_decap_8
XFILLER_48_869 VPWR VGND sg13g2_decap_8
XFILLER_47_357 VPWR VGND sg13g2_decap_8
XFILLER_12_994 VPWR VGND sg13g2_decap_8
XFILLER_16_788 VPWR VGND sg13g2_decap_8
XFILLER_8_910 VPWR VGND sg13g2_decap_8
XFILLER_3_681 VPWR VGND sg13g2_decap_8
XFILLER_8_987 VPWR VGND sg13g2_decap_8
XFILLER_39_847 VPWR VGND sg13g2_decap_4
Xclkbuf_leaf_2_clk _256_/B delaybuf_10_clk/A VPWR VGND sg13g2_buf_8
XFILLER_0_1014 VPWR VGND sg13g2_decap_8
XFILLER_22_769 VPWR VGND sg13g2_fill_1
XFILLER_30_791 VPWR VGND sg13g2_decap_8
XFILLER_1_607 VPWR VGND sg13g2_decap_8
XFILLER_21_791 VPWR VGND sg13g2_decap_8
XFILLER_44_56 VPWR VGND sg13g2_fill_2
XFILLER_5_968 VPWR VGND sg13g2_decap_8
XFILLER_48_622 VPWR VGND sg13g2_decap_8
XFILLER_44_850 VPWR VGND sg13g2_fill_2
XFILLER_48_699 VPWR VGND sg13g2_decap_8
XFILLER_12_791 VPWR VGND sg13g2_decap_8
XFILLER_8_784 VPWR VGND sg13g2_decap_8
XFILLER_22_0 VPWR VGND sg13g2_fill_1
Xu_custom_cells.u_final_mux.SwitchMatrixMultiplexer_inv_inst _577_/Q _284_/B2 VPWR
+ _288_/B2 _280_/A1 VGND _575_/Q SwitchMatrixMultiplexer_inv
X_610_ _610_/Q _610_/CLK _610_/D fanout65/X VPWR VGND sg13g2_dfrbpq_1
XFILLER_41_820 VPWR VGND sg13g2_decap_8
XFILLER_45_658 VPWR VGND sg13g2_decap_8
X_541_ _541_/Q _656_/CLK _541_/D fanout75/X VPWR VGND sg13g2_dfrbpq_1
X_472_ _472_/Q _660_/CLK _472_/D fanout80/X VPWR VGND sg13g2_dfrbpq_1
Xdelaybuf_7_clk delaybuf_8_clk/A delaybuf_7_clk/A VPWR VGND sg13g2_buf_16
XFILLER_1_971 VPWR VGND sg13g2_decap_8
XFILLER_5_765 VPWR VGND sg13g2_decap_8
XFILLER_48_441 VPWR VGND sg13g2_decap_8
Xu_custom_cells.u_mux1.mux_inv_inst _286_/B2 VPWR VGND _574_/Q _573_/Q _572_/Q mux_inv
XFILLER_23_820 VPWR VGND sg13g2_decap_8
XFILLER_42_639 VPWR VGND sg13g2_decap_8
XFILLER_1_223 VPWR VGND sg13g2_fill_2
XFILLER_2_757 VPWR VGND sg13g2_decap_8
XFILLER_45_455 VPWR VGND sg13g2_decap_8
XFILLER_14_875 VPWR VGND sg13g2_decap_8
XFILLER_41_694 VPWR VGND sg13g2_decap_8
X_524_ _524_/Q _610_/CLK _524_/D fanout69/X VPWR VGND sg13g2_dfrbpq_1
X_455_ _455_/Y _456_/A _456_/B VPWR VGND sg13g2_xnor2_1
X_386_ _551_/D _550_/Q _551_/Q _398_/S VPWR VGND sg13g2_mux2_1
XFILLER_5_562 VPWR VGND sg13g2_decap_8
XFILLER_20_823 VPWR VGND sg13g2_decap_8
XFILLER_11_812 VPWR VGND sg13g2_decap_8
XFILLER_42_403 VPWR VGND sg13g2_fill_1
X_240_ _240_/X _655_/Q _255_/B VPWR VGND sg13g2_and2_1
XFILLER_11_889 VPWR VGND sg13g2_decap_8
XFILLER_6_326 VPWR VGND sg13g2_fill_1
XFILLER_2_554 VPWR VGND sg13g2_decap_8
XFILLER_45_285 VPWR VGND sg13g2_decap_8
XFILLER_46_786 VPWR VGND sg13g2_decap_8
X_507_ _507_/Q _609_/CLK _507_/D fanout73/X VPWR VGND sg13g2_dfrbpq_1
X_438_ _438_/Y _441_/A _458_/B VPWR VGND sg13g2_xnor2_1
X_369_ _534_/D _533_/Q _534_/Q _369_/S VPWR VGND sg13g2_mux2_1
XFILLER_5_392 VPWR VGND sg13g2_fill_1
XFILLER_16_926 VPWR VGND sg13g2_fill_2
XFILLER_28_797 VPWR VGND sg13g2_decap_8
XFILLER_47_539 VPWR VGND sg13g2_decap_8
XFILLER_43_756 VPWR VGND sg13g2_decap_8
X_223_ _223_/Y _650_/Q VPWR VGND sg13g2_inv_1
XFILLER_3_863 VPWR VGND sg13g2_decap_8
XFILLER_7_657 VPWR VGND sg13g2_decap_8
XFILLER_2_351 VPWR VGND sg13g2_fill_1
XFILLER_34_756 VPWR VGND sg13g2_decap_8
XFILLER_46_550 VPWR VGND sg13g2_decap_8
XFILLER_25_756 VPWR VGND sg13g2_decap_8
XFILLER_4_638 VPWR VGND sg13g2_decap_8
XFILLER_0_811 VPWR VGND sg13g2_decap_8
XFILLER_0_888 VPWR VGND sg13g2_decap_8
Xu_clkbuf_analog_pin2.u_buf analog_pin2 _441_/A VPWR VGND sg13g2_buf_16
XFILLER_48_804 VPWR VGND sg13g2_decap_8
XFILLER_47_336 VPWR VGND sg13g2_decap_8
XFILLER_12_973 VPWR VGND sg13g2_decap_8
XFILLER_43_597 VPWR VGND sg13g2_decap_8
XFILLER_8_966 VPWR VGND sg13g2_decap_8
XFILLER_7_476 VPWR VGND sg13g2_decap_8
XFILLER_7_454 VPWR VGND sg13g2_decap_4
XFILLER_7_443 VPWR VGND sg13g2_fill_1
XFILLER_3_660 VPWR VGND sg13g2_decap_8
XFILLER_0_40 VPWR VGND sg13g2_fill_2
XFILLER_39_826 VPWR VGND sg13g2_decap_8
XFILLER_46_380 VPWR VGND sg13g2_decap_8
XFILLER_30_770 VPWR VGND sg13g2_decap_8
XFILLER_21_770 VPWR VGND sg13g2_decap_8
XFILLER_5_947 VPWR VGND sg13g2_decap_8
XFILLER_4_435 VPWR VGND sg13g2_decap_8
XFILLER_0_685 VPWR VGND sg13g2_decap_8
XFILLER_36_829 VPWR VGND sg13g2_fill_2
XFILLER_48_678 VPWR VGND sg13g2_decap_8
XFILLER_48_601 VPWR VGND sg13g2_decap_8
XFILLER_15_1012 VPWR VGND sg13g2_decap_8
XFILLER_12_770 VPWR VGND sg13g2_decap_8
XFILLER_8_763 VPWR VGND sg13g2_decap_8
XFILLER_35_851 VPWR VGND sg13g2_fill_1
XFILLER_14_27 VPWR VGND sg13g2_fill_1
Xu_custom_cells.u_latch0.latch_inst _284_/B2 _282_/B2 VGND VPWR _577_/Q latch
XFILLER_2_939 VPWR VGND sg13g2_decap_8
XFILLER_45_637 VPWR VGND sg13g2_decap_8
X_540_ _540_/Q _626_/CLK _540_/D fanout70/X VPWR VGND sg13g2_dfrbpq_1
XFILLER_26_840 VPWR VGND sg13g2_decap_8
XFILLER_26_851 VPWR VGND sg13g2_fill_1
X_471_ _471_/Q _577_/CLK _471_/D fanout80/X VPWR VGND sg13g2_dfrbpq_1
XFILLER_5_744 VPWR VGND sg13g2_decap_8
XFILLER_0_482 VPWR VGND sg13g2_decap_8
XFILLER_1_950 VPWR VGND sg13g2_decap_8
XFILLER_49_910 VPWR VGND sg13g2_decap_8
XFILLER_48_420 VPWR VGND sg13g2_decap_8
XFILLER_48_497 VPWR VGND sg13g2_decap_8
XFILLER_44_692 VPWR VGND sg13g2_decap_8
XFILLER_6_61 VPWR VGND sg13g2_fill_1
XFILLER_6_1010 VPWR VGND sg13g2_decap_8
XFILLER_42_618 VPWR VGND sg13g2_decap_8
XFILLER_2_736 VPWR VGND sg13g2_decap_8
XFILLER_45_434 VPWR VGND sg13g2_decap_8
X_523_ _523_/Q _611_/CLK _523_/D fanout68/X VPWR VGND sg13g2_dfrbpq_1
XFILLER_14_854 VPWR VGND sg13g2_decap_8
XFILLER_41_673 VPWR VGND sg13g2_decap_8
X_454_ _454_/Y _456_/A _456_/B VPWR VGND sg13g2_xnor2_1
X_385_ _550_/D _549_/Q _550_/Q _398_/S VPWR VGND sg13g2_mux2_1
XFILLER_12_1015 VPWR VGND sg13g2_decap_8
XFILLER_5_541 VPWR VGND sg13g2_decap_8
XFILLER_49_784 VPWR VGND sg13g2_decap_8
XFILLER_48_294 VPWR VGND sg13g2_decap_8
XFILLER_20_802 VPWR VGND sg13g2_decap_8
XFILLER_11_868 VPWR VGND sg13g2_decap_8
XFILLER_2_533 VPWR VGND sg13g2_decap_8
XFILLER_7_839 VPWR VGND sg13g2_decap_8
XFILLER_45_264 VPWR VGND sg13g2_decap_8
X_506_ _506_/Q _581_/CLK _506_/D fanout85/X VPWR VGND sg13g2_dfrbpq_1
XFILLER_46_765 VPWR VGND sg13g2_decap_8
X_437_ _602_/D _291_/B _295_/Y _602_/Q VPWR VGND sg13g2_a21o_1
X_368_ _533_/D _532_/Q _533_/Q _412_/S VPWR VGND sg13g2_mux2_1
X_299_ _300_/B _218_/Y _297_/B _304_/A VPWR VGND sg13g2_o21ai_1
XFILLER_3_1024 VPWR VGND sg13g2_decap_4
XFILLER_49_581 VPWR VGND sg13g2_decap_8
XFILLER_37_798 VPWR VGND sg13g2_decap_8
XFILLER_28_776 VPWR VGND sg13g2_decap_8
XFILLER_43_735 VPWR VGND sg13g2_decap_8
X_222_ _222_/Y _604_/Q VPWR VGND sg13g2_inv_1
XFILLER_7_636 VPWR VGND sg13g2_decap_8
XFILLER_3_842 VPWR VGND sg13g2_decap_8
XFILLER_33_37 VPWR VGND sg13g2_fill_2
XFILLER_4_617 VPWR VGND sg13g2_decap_8
XFILLER_0_867 VPWR VGND sg13g2_decap_8
XFILLER_47_315 VPWR VGND sg13g2_decap_8
XFILLER_31_749 VPWR VGND sg13g2_decap_8
XFILLER_43_576 VPWR VGND sg13g2_decap_8
XFILLER_12_952 VPWR VGND sg13g2_decap_8
XFILLER_8_945 VPWR VGND sg13g2_decap_8
XFILLER_39_805 VPWR VGND sg13g2_decap_8
XFILLER_22_749 VPWR VGND sg13g2_decap_4
Xdelaybuf_26_clk delaybuf_27_clk/A delaybuf_26_clk/A VPWR VGND sg13g2_buf_16
XFILLER_45_819 VPWR VGND sg13g2_decap_8
XFILLER_13_749 VPWR VGND sg13g2_decap_8
XFILLER_5_926 VPWR VGND sg13g2_decap_8
XFILLER_0_664 VPWR VGND sg13g2_decap_8
Xdelaybuf_17_clk delaybuf_18_clk/A clkbuf_0_clk/X VPWR VGND sg13g2_buf_16
XFILLER_36_808 VPWR VGND sg13g2_decap_8
XFILLER_48_657 VPWR VGND sg13g2_decap_8
XFILLER_43_340 VPWR VGND sg13g2_fill_2
XFILLER_7_296 VPWR VGND sg13g2_decap_8
XFILLER_4_981 VPWR VGND sg13g2_decap_8
XFILLER_27_819 VPWR VGND sg13g2_decap_4
XFILLER_35_830 VPWR VGND sg13g2_decap_8
Xu_clkbuf_analog_pin1.u_buf analog_pin1 _282_/A1 VPWR VGND sg13g2_buf_16
XFILLER_1_439 VPWR VGND sg13g2_decap_8
XFILLER_2_918 VPWR VGND sg13g2_decap_8
XFILLER_18_819 VPWR VGND sg13g2_decap_8
XFILLER_45_616 VPWR VGND sg13g2_decap_8
X_470_ _470_/Q _658_/CLK _470_/D fanout80/X VPWR VGND sg13g2_dfrbpq_1
XFILLER_5_723 VPWR VGND sg13g2_decap_8
XFILLER_0_461 VPWR VGND sg13g2_decap_8
XFILLER_49_966 VPWR VGND sg13g2_decap_8
XFILLER_44_671 VPWR VGND sg13g2_decap_8
X_599_ _599_/Q _629_/CLK _599_/D fanout64/X VPWR VGND sg13g2_dfrbpq_1
XFILLER_48_476 VPWR VGND sg13g2_decap_8
XFILLER_2_715 VPWR VGND sg13g2_decap_8
XFILLER_1_225 VPWR VGND sg13g2_fill_1
XFILLER_14_833 VPWR VGND sg13g2_decap_8
XFILLER_45_413 VPWR VGND sg13g2_decap_8
X_522_ _522_/Q _649_/CLK _522_/D fanout82/X VPWR VGND sg13g2_dfrbpq_1
X_453_ _453_/Y _453_/A _456_/B VPWR VGND sg13g2_xnor2_1
XFILLER_41_652 VPWR VGND sg13g2_decap_8
X_384_ _549_/D _548_/Q _549_/Q _397_/S VPWR VGND sg13g2_mux2_1
XFILLER_5_597 VPWR VGND sg13g2_decap_8
XFILLER_5_520 VPWR VGND sg13g2_decap_8
XFILLER_49_763 VPWR VGND sg13g2_decap_8
XFILLER_48_273 VPWR VGND sg13g2_decap_8
Xclkbuf_4_0_0_clk_regs clkbuf_4_0_0_clk_regs/X clkbuf_0_clk_regs/X VPWR VGND sg13g2_buf_8
XFILLER_11_847 VPWR VGND sg13g2_decap_8
XFILLER_7_818 VPWR VGND sg13g2_decap_8
XFILLER_2_512 VPWR VGND sg13g2_decap_8
XFILLER_2_589 VPWR VGND sg13g2_decap_8
XFILLER_46_744 VPWR VGND sg13g2_decap_8
X_505_ _505_/Q _581_/CLK _505_/D fanout86/X VPWR VGND sg13g2_dfrbpq_1
X_436_ _601_/D _629_/D _601_/Q _436_/S VPWR VGND sg13g2_mux2_1
X_367_ _532_/D _531_/Q _532_/Q _412_/S VPWR VGND sg13g2_mux2_1
X_298_ _302_/B _469_/Q _470_/Q _311_/S VPWR VGND sg13g2_nand3_1
XFILLER_3_74 VPWR VGND sg13g2_fill_1
XFILLER_6_884 VPWR VGND sg13g2_decap_8
XFILLER_37_777 VPWR VGND sg13g2_decap_8
XFILLER_3_1003 VPWR VGND sg13g2_decap_8
XFILLER_3_85 VPWR VGND sg13g2_fill_2
XFILLER_49_560 VPWR VGND sg13g2_decap_8
XFILLER_42_202 VPWR VGND sg13g2_fill_2
XFILLER_43_714 VPWR VGND sg13g2_decap_8
X_221_ _647_/D _278_/S VPWR VGND sg13g2_inv_1
XFILLER_7_615 VPWR VGND sg13g2_decap_8
XFILLER_2_386 VPWR VGND sg13g2_fill_2
XFILLER_3_821 VPWR VGND sg13g2_decap_8
XFILLER_3_898 VPWR VGND sg13g2_decap_8
XFILLER_5_0 VPWR VGND sg13g2_fill_2
XFILLER_19_788 VPWR VGND sg13g2_decap_8
XFILLER_46_585 VPWR VGND sg13g2_decap_8
X_419_ _584_/D _583_/Q _584_/Q _435_/S VPWR VGND sg13g2_mux2_1
XFILLER_6_681 VPWR VGND sg13g2_decap_8
Xclkbuf_leaf_5_clk _452_/B delaybuf_16_clk/X VPWR VGND sg13g2_buf_8
XFILLER_33_27 VPWR VGND sg13g2_fill_1
Xclkbuf_5_19__f_clk_regs _630_/CLK clkbuf_4_9_0_clk_regs/X VPWR VGND sg13g2_buf_16
XFILLER_0_846 VPWR VGND sg13g2_decap_8
XFILLER_48_839 VPWR VGND sg13g2_decap_8
XFILLER_12_931 VPWR VGND sg13g2_decap_8
XFILLER_24_791 VPWR VGND sg13g2_decap_8
XFILLER_43_555 VPWR VGND sg13g2_decap_8
XFILLER_8_924 VPWR VGND sg13g2_decap_8
XFILLER_7_401 VPWR VGND sg13g2_fill_1
XFILLER_48_1015 VPWR VGND sg13g2_decap_8
XFILLER_3_695 VPWR VGND sg13g2_decap_8
XFILLER_0_1028 VPWR VGND sg13g2_fill_1
XFILLER_0_42 VPWR VGND sg13g2_fill_1
XFILLER_47_894 VPWR VGND sg13g2_decap_4
XFILLER_15_780 VPWR VGND sg13g2_decap_8
XFILLER_5_905 VPWR VGND sg13g2_decap_8
XFILLER_0_643 VPWR VGND sg13g2_decap_8
Xclkbuf_4_13_0_clk_regs clkbuf_4_13_0_clk_regs/X clkbuf_0_clk_regs/X VPWR VGND sg13g2_buf_8
XFILLER_48_636 VPWR VGND sg13g2_decap_8
XFILLER_43_385 VPWR VGND sg13g2_decap_8
XFILLER_8_798 VPWR VGND sg13g2_decap_8
XFILLER_4_960 VPWR VGND sg13g2_decap_8
XFILLER_3_492 VPWR VGND sg13g2_decap_8
XFILLER_41_834 VPWR VGND sg13g2_decap_8
XFILLER_5_779 VPWR VGND sg13g2_decap_8
XFILLER_5_702 VPWR VGND sg13g2_decap_8
XFILLER_0_440 VPWR VGND sg13g2_decap_8
XFILLER_1_985 VPWR VGND sg13g2_decap_8
XFILLER_48_455 VPWR VGND sg13g2_decap_8
XFILLER_44_650 VPWR VGND sg13g2_decap_8
X_598_ _598_/Q _630_/CLK _598_/D fanout64/X VPWR VGND sg13g2_dfrbpq_1
XANTENNA_1 ena VPWR VGND sg13g2_antennanp
XFILLER_23_834 VPWR VGND sg13g2_decap_8
XFILLER_14_812 VPWR VGND sg13g2_decap_8
XFILLER_41_631 VPWR VGND sg13g2_decap_8
XFILLER_45_469 VPWR VGND sg13g2_decap_4
X_521_ _521_/Q _577_/CLK _521_/D fanout83/X VPWR VGND sg13g2_dfrbpq_1
X_452_ _452_/Y _453_/A _452_/B VPWR VGND sg13g2_xnor2_1
X_383_ _548_/D _547_/Q _548_/Q _397_/S VPWR VGND sg13g2_mux2_1
XFILLER_14_889 VPWR VGND sg13g2_decap_8
Xu_clkbuf_analog_pin0.u_buf analog_pin0 _280_/A0 VPWR VGND sg13g2_buf_16
XFILLER_5_576 VPWR VGND sg13g2_decap_8
XFILLER_1_782 VPWR VGND sg13g2_decap_8
XFILLER_49_742 VPWR VGND sg13g2_decap_8
XFILLER_48_230 VPWR VGND sg13g2_fill_2
XFILLER_20_848 VPWR VGND sg13g2_decap_4
XFILLER_9_882 VPWR VGND sg13g2_decap_8
XFILLER_11_826 VPWR VGND sg13g2_decap_8
XFILLER_2_568 VPWR VGND sg13g2_decap_8
XFILLER_46_723 VPWR VGND sg13g2_decap_8
XFILLER_45_299 VPWR VGND sg13g2_decap_8
X_504_ _504_/Q _581_/CLK _504_/D fanout86/X VPWR VGND sg13g2_dfrbpq_1
X_435_ _600_/D _599_/Q _629_/D _435_/S VPWR VGND sg13g2_mux2_1
X_366_ _531_/D _530_/Q _531_/Q _366_/S VPWR VGND sg13g2_mux2_1
X_297_ _469_/D _469_/Q _297_/B VPWR VGND sg13g2_xnor2_1
XFILLER_6_863 VPWR VGND sg13g2_decap_8
XFILLER_5_362 VPWR VGND sg13g2_fill_2
XFILLER_47_5 VPWR VGND sg13g2_fill_2
XFILLER_37_756 VPWR VGND sg13g2_decap_8
Xclkbuf_5_18__f_clk_regs _615_/CLK clkbuf_4_9_0_clk_regs/X VPWR VGND sg13g2_buf_16
X_220_ _220_/Y _472_/Q VPWR VGND sg13g2_inv_1
XFILLER_3_800 VPWR VGND sg13g2_decap_8
XFILLER_3_877 VPWR VGND sg13g2_decap_8
XFILLER_46_564 VPWR VGND sg13g2_decap_8
X_418_ _583_/D _609_/D _583_/Q _429_/S VPWR VGND sg13g2_mux2_1
X_349_ _514_/D _513_/Q _514_/Q _350_/S VPWR VGND sg13g2_mux2_1
XFILLER_6_660 VPWR VGND sg13g2_decap_8
XFILLER_0_825 VPWR VGND sg13g2_decap_8
XFILLER_48_818 VPWR VGND sg13g2_decap_8
XFILLER_12_910 VPWR VGND sg13g2_decap_8
XFILLER_12_987 VPWR VGND sg13g2_decap_8
XFILLER_24_770 VPWR VGND sg13g2_decap_8
XFILLER_8_903 VPWR VGND sg13g2_decap_8
XFILLER_17_6 VPWR VGND sg13g2_fill_1
XFILLER_3_674 VPWR VGND sg13g2_decap_8
XFILLER_47_840 VPWR VGND sg13g2_decap_8
XFILLER_0_1007 VPWR VGND sg13g2_decap_8
XFILLER_46_394 VPWR VGND sg13g2_decap_8
XFILLER_30_784 VPWR VGND sg13g2_decap_8
XFILLER_38_840 VPWR VGND sg13g2_decap_8
XFILLER_38_851 VPWR VGND sg13g2_fill_1
XFILLER_21_784 VPWR VGND sg13g2_decap_8
XFILLER_4_449 VPWR VGND sg13g2_fill_1
XFILLER_0_622 VPWR VGND sg13g2_decap_8
XFILLER_0_699 VPWR VGND sg13g2_decap_8
XFILLER_48_615 VPWR VGND sg13g2_decap_8
XFILLER_43_342 VPWR VGND sg13g2_fill_1
XFILLER_44_832 VPWR VGND sg13g2_decap_8
XFILLER_12_784 VPWR VGND sg13g2_decap_8
XFILLER_15_1026 VPWR VGND sg13g2_fill_2
XFILLER_8_777 VPWR VGND sg13g2_decap_8
XFILLER_7_254 VPWR VGND sg13g2_decap_4
XFILLER_41_813 VPWR VGND sg13g2_decap_8
Xclkbuf_regs_1_clk clkbuf_regs_1_clk/X _256_/Y VPWR VGND sg13g2_buf_16
XFILLER_5_758 VPWR VGND sg13g2_decap_8
XFILLER_0_496 VPWR VGND sg13g2_decap_8
XFILLER_1_964 VPWR VGND sg13g2_decap_8
XFILLER_49_924 VPWR VGND sg13g2_decap_4
XFILLER_48_434 VPWR VGND sg13g2_decap_8
XFILLER_32_813 VPWR VGND sg13g2_fill_2
X_597_ _626_/D _610_/CLK _597_/D fanout65/X VPWR VGND sg13g2_dfrbpq_1
XANTENNA_2 ui_in[5] VPWR VGND sg13g2_antennanp
XFILLER_6_20 VPWR VGND sg13g2_fill_2
XFILLER_6_1024 VPWR VGND sg13g2_decap_4
XFILLER_13_0 VPWR VGND sg13g2_fill_2
XFILLER_23_813 VPWR VGND sg13g2_decap_8
X_520_ _520_/Q _571_/CLK _520_/D fanout83/X VPWR VGND sg13g2_dfrbpq_1
XFILLER_14_868 VPWR VGND sg13g2_decap_8
XFILLER_41_610 VPWR VGND sg13g2_decap_8
XFILLER_45_448 VPWR VGND sg13g2_decap_8
X_451_ _451_/Y _456_/A _452_/B VPWR VGND sg13g2_xnor2_1
X_382_ _547_/D _546_/Q _547_/Q _397_/S VPWR VGND sg13g2_mux2_1
XFILLER_41_687 VPWR VGND sg13g2_decap_8
XFILLER_5_555 VPWR VGND sg13g2_decap_8
XFILLER_1_761 VPWR VGND sg13g2_decap_8
XFILLER_49_721 VPWR VGND sg13g2_decap_8
X_649_ _649_/Q _649_/CLK _649_/D fanout79/X VPWR VGND sg13g2_dfrbpq_1
XFILLER_49_798 VPWR VGND sg13g2_decap_8
XFILLER_20_816 VPWR VGND sg13g2_decap_8
Xclkbuf_5_17__f_clk_regs _609_/CLK clkbuf_4_8_0_clk_regs/X VPWR VGND sg13g2_buf_16
XFILLER_9_861 VPWR VGND sg13g2_decap_8
Xu_custom_cells.u_mux0.mux_inst VGND VPWR _288_/B2 _570_/Q _574_/Q _571_/Q mux
XFILLER_11_805 VPWR VGND sg13g2_decap_8
XFILLER_2_547 VPWR VGND sg13g2_decap_8
XFILLER_45_278 VPWR VGND sg13g2_decap_8
X_503_ _503_/Q _581_/CLK _503_/D fanout86/X VPWR VGND sg13g2_dfrbpq_1
XFILLER_46_779 VPWR VGND sg13g2_decap_8
XFILLER_46_702 VPWR VGND sg13g2_decap_8
X_434_ _599_/D _598_/Q _599_/Q _435_/S VPWR VGND sg13g2_mux2_1
X_365_ _530_/D _529_/Q _530_/Q _366_/S VPWR VGND sg13g2_mux2_1
X_296_ _297_/B _295_/A _295_/B _311_/S VPWR VGND sg13g2_o21ai_1
XFILLER_10_882 VPWR VGND sg13g2_decap_8
XFILLER_6_842 VPWR VGND sg13g2_decap_8
XFILLER_3_87 VPWR VGND sg13g2_fill_1
XFILLER_49_595 VPWR VGND sg13g2_decap_8
XFILLER_16_919 VPWR VGND sg13g2_decap_8
XFILLER_43_749 VPWR VGND sg13g2_decap_8
XFILLER_3_856 VPWR VGND sg13g2_decap_8
XFILLER_2_388 VPWR VGND sg13g2_fill_1
XFILLER_2_399 VPWR VGND sg13g2_decap_4
XFILLER_34_749 VPWR VGND sg13g2_decap_8
XFILLER_46_543 VPWR VGND sg13g2_decap_8
XFILLER_42_793 VPWR VGND sg13g2_decap_8
X_417_ _582_/D _608_/D _609_/D _429_/S VPWR VGND sg13g2_mux2_1
X_348_ _513_/D _512_/Q _513_/Q _350_/S VPWR VGND sg13g2_mux2_1
X_279_ _279_/Y _281_/A _279_/B VPWR VGND sg13g2_nor2_1
XFILLER_49_392 VPWR VGND sg13g2_decap_8
XFILLER_25_749 VPWR VGND sg13g2_decap_8
XFILLER_0_804 VPWR VGND sg13g2_decap_8
XFILLER_47_329 VPWR VGND sg13g2_decap_8
XFILLER_12_966 VPWR VGND sg13g2_decap_8
XFILLER_8_959 VPWR VGND sg13g2_decap_8
XFILLER_7_436 VPWR VGND sg13g2_decap_8
XFILLER_3_653 VPWR VGND sg13g2_decap_8
XFILLER_7_469 VPWR VGND sg13g2_decap_8
XFILLER_39_819 VPWR VGND sg13g2_decap_8
Xu_custom_cells.u_latmux.SwitchMatrixMultiplexer_inst _576_/Q VGND VPWR _288_/B2 _286_/B2
+ _282_/B2 _575_/Q SwitchMatrixMultiplexer
XFILLER_42_590 VPWR VGND sg13g2_decap_8
XFILLER_46_373 VPWR VGND sg13g2_decap_8
XFILLER_30_763 VPWR VGND sg13g2_decap_8
XFILLER_9_1022 VPWR VGND sg13g2_decap_8
XFILLER_21_763 VPWR VGND sg13g2_decap_8
XFILLER_0_601 VPWR VGND sg13g2_decap_8
XFILLER_4_428 VPWR VGND sg13g2_decap_8
XFILLER_0_678 VPWR VGND sg13g2_decap_8
XFILLER_44_811 VPWR VGND sg13g2_decap_8
XFILLER_12_763 VPWR VGND sg13g2_decap_8
XFILLER_8_756 VPWR VGND sg13g2_decap_8
XFILLER_4_995 VPWR VGND sg13g2_decap_8
XFILLER_35_844 VPWR VGND sg13g2_decap_8
XFILLER_47_693 VPWR VGND sg13g2_decap_8
XFILLER_26_833 VPWR VGND sg13g2_decap_8
XFILLER_5_737 VPWR VGND sg13g2_decap_8
XFILLER_4_203 VPWR VGND sg13g2_fill_1
XFILLER_1_943 VPWR VGND sg13g2_decap_8
XFILLER_49_903 VPWR VGND sg13g2_decap_8
XFILLER_0_475 VPWR VGND sg13g2_decap_8
XFILLER_48_413 VPWR VGND sg13g2_decap_8
XFILLER_44_685 VPWR VGND sg13g2_decap_8
X_596_ _625_/D _615_/CLK _596_/D fanout65/X VPWR VGND sg13g2_dfrbpq_1
Xclkbuf_5_16__f_clk_regs _623_/CLK clkbuf_4_8_0_clk_regs/X VPWR VGND sg13g2_buf_16
XANTENNA_3 uio_in[0] VPWR VGND sg13g2_antennanp
XFILLER_6_1003 VPWR VGND sg13g2_decap_8
XFILLER_4_792 VPWR VGND sg13g2_decap_8
XFILLER_2_729 VPWR VGND sg13g2_decap_8
XFILLER_45_427 VPWR VGND sg13g2_decap_8
XFILLER_14_847 VPWR VGND sg13g2_decap_8
XFILLER_41_666 VPWR VGND sg13g2_decap_8
X_450_ _450_/Y _456_/A _452_/B VPWR VGND sg13g2_xnor2_1
X_381_ _546_/D _545_/Q _546_/Q _397_/S VPWR VGND sg13g2_mux2_1
XFILLER_12_1008 VPWR VGND sg13g2_decap_8
XFILLER_5_534 VPWR VGND sg13g2_decap_8
XFILLER_1_740 VPWR VGND sg13g2_decap_8
XFILLER_49_777 VPWR VGND sg13g2_decap_8
XFILLER_49_700 VPWR VGND sg13g2_decap_8
X_648_ _648_/Q _648_/CLK _648_/D fanout81/X VPWR VGND sg13g2_dfrbpq_1
XFILLER_48_287 VPWR VGND sg13g2_decap_8
X_579_ _579_/Q _606_/CLK _579_/D fanout85/X VPWR VGND sg13g2_dfrbpq_1
XFILLER_9_840 VPWR VGND sg13g2_decap_8
XFILLER_2_526 VPWR VGND sg13g2_decap_8
Xdelaybuf_0_clk delaybuf_0_clk/X u_delay_line/clk VPWR VGND sg13g2_buf_16
X_502_ _502_/Q _581_/CLK _502_/D fanout86/X VPWR VGND sg13g2_dfrbpq_1
X_433_ _598_/D _626_/D _598_/Q _435_/S VPWR VGND sg13g2_mux2_1
XFILLER_46_758 VPWR VGND sg13g2_decap_8
XFILLER_10_861 VPWR VGND sg13g2_decap_8
X_364_ _529_/D _528_/Q _529_/Q _375_/S VPWR VGND sg13g2_mux2_1
X_295_ _295_/Y _295_/A _295_/B VPWR VGND sg13g2_nor2_1
XFILLER_6_821 VPWR VGND sg13g2_decap_8
XFILLER_6_898 VPWR VGND sg13g2_decap_8
XFILLER_5_364 VPWR VGND sg13g2_fill_1
XFILLER_3_1017 VPWR VGND sg13g2_decap_8
XFILLER_3_1028 VPWR VGND sg13g2_fill_1
XFILLER_49_574 VPWR VGND sg13g2_decap_8
XFILLER_45_791 VPWR VGND sg13g2_decap_8
XFILLER_28_769 VPWR VGND sg13g2_decap_8
XFILLER_43_728 VPWR VGND sg13g2_decap_8
XFILLER_7_629 VPWR VGND sg13g2_decap_8
XFILLER_3_835 VPWR VGND sg13g2_decap_8
XFILLER_27_791 VPWR VGND sg13g2_decap_8
XFILLER_42_772 VPWR VGND sg13g2_decap_8
X_416_ _581_/D _580_/Q _608_/D _416_/S VPWR VGND sg13g2_mux2_1
XFILLER_46_599 VPWR VGND sg13g2_decap_8
X_347_ _512_/D _511_/Q _512_/Q _350_/S VPWR VGND sg13g2_mux2_1
X_278_ _634_/D _612_/Q _626_/Q _278_/S VPWR VGND sg13g2_mux2_1
XFILLER_2_890 VPWR VGND sg13g2_decap_8
XFILLER_6_695 VPWR VGND sg13g2_decap_8
XFILLER_49_371 VPWR VGND sg13g2_decap_8
XFILLER_18_791 VPWR VGND sg13g2_decap_8
XFILLER_33_783 VPWR VGND sg13g2_decap_4
XFILLER_47_308 VPWR VGND sg13g2_decap_8
XFILLER_43_569 VPWR VGND sg13g2_decap_8
XFILLER_12_945 VPWR VGND sg13g2_decap_8
XFILLER_8_938 VPWR VGND sg13g2_decap_8
XFILLER_3_632 VPWR VGND sg13g2_decap_8
XFILLER_0_78 VPWR VGND sg13g2_fill_2
XFILLER_46_352 VPWR VGND sg13g2_decap_8
XFILLER_15_794 VPWR VGND sg13g2_decap_8
XFILLER_7_993 VPWR VGND sg13g2_decap_8
XFILLER_9_1001 VPWR VGND sg13g2_decap_8
XFILLER_5_919 VPWR VGND sg13g2_decap_8
XFILLER_0_657 VPWR VGND sg13g2_decap_8
XFILLER_15_1028 VPWR VGND sg13g2_fill_1
XFILLER_43_333 VPWR VGND sg13g2_decap_8
XFILLER_43_399 VPWR VGND sg13g2_decap_8
Xclkbuf_5_15__f_clk_regs _557_/CLK clkbuf_4_7_0_clk_regs/X VPWR VGND sg13g2_buf_16
XFILLER_7_289 VPWR VGND sg13g2_decap_8
XFILLER_7_267 VPWR VGND sg13g2_decap_4
XFILLER_7_223 VPWR VGND sg13g2_decap_4
XFILLER_3_462 VPWR VGND sg13g2_fill_2
XFILLER_4_974 VPWR VGND sg13g2_decap_8
XFILLER_35_823 VPWR VGND sg13g2_decap_8
XFILLER_47_672 VPWR VGND sg13g2_decap_8
XFILLER_7_790 VPWR VGND sg13g2_decap_8
XFILLER_26_812 VPWR VGND sg13g2_decap_8
XFILLER_45_609 VPWR VGND sg13g2_decap_8
XFILLER_41_848 VPWR VGND sg13g2_decap_4
XFILLER_5_716 VPWR VGND sg13g2_decap_8
XFILLER_0_454 VPWR VGND sg13g2_decap_8
XFILLER_1_922 VPWR VGND sg13g2_decap_8
XFILLER_1_999 VPWR VGND sg13g2_decap_8
XFILLER_17_812 VPWR VGND sg13g2_decap_8
XFILLER_44_664 VPWR VGND sg13g2_decap_8
X_595_ _624_/D _623_/CLK _595_/D fanout67/X VPWR VGND sg13g2_dfrbpq_1
XFILLER_48_469 VPWR VGND sg13g2_decap_8
XFILLER_3_270 VPWR VGND sg13g2_fill_2
XFILLER_4_771 VPWR VGND sg13g2_decap_8
XFILLER_23_848 VPWR VGND sg13g2_decap_4
Xclkbuf_4_12_0_clk_regs clkbuf_4_12_0_clk_regs/X clkbuf_0_clk_regs/X VPWR VGND sg13g2_buf_8
XFILLER_2_708 VPWR VGND sg13g2_decap_8
XFILLER_45_406 VPWR VGND sg13g2_decap_8
XFILLER_14_826 VPWR VGND sg13g2_decap_8
XFILLER_41_645 VPWR VGND sg13g2_decap_8
X_380_ _545_/D _544_/Q _545_/Q _391_/S VPWR VGND sg13g2_mux2_1
Xoutput30 uo_out[0] _280_/X VPWR VGND sg13g2_buf_1
XFILLER_1_796 VPWR VGND sg13g2_decap_8
XFILLER_49_756 VPWR VGND sg13g2_decap_8
XFILLER_48_266 VPWR VGND sg13g2_decap_8
XFILLER_44_461 VPWR VGND sg13g2_decap_8
X_578_ _578_/Q _606_/CLK _578_/D fanout73/X VPWR VGND sg13g2_dfrbpq_1
X_647_ _647_/Q _647_/CLK _647_/D fanout76/X VPWR VGND sg13g2_dfrbpq_1
XFILLER_9_896 VPWR VGND sg13g2_decap_8
.ends
