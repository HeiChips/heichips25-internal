* NGSPICE file created from heichips25_internal.ext - technology: ihp-sg13g2

* Black-box entry subcircuit for sg13g2_decap_8 abstract view
.subckt sg13g2_decap_8 VDD VSS
.ends

* Black-box entry subcircuit for sg13g2_dfrbpq_1 abstract view
.subckt sg13g2_dfrbpq_1 Q CLK D RESET_B VDD VSS
.ends

* Black-box entry subcircuit for sg13g2_mux2_1 abstract view
.subckt sg13g2_mux2_1 X A0 A1 S VDD VSS
.ends

* Black-box entry subcircuit for sg13g2_nand4_1 abstract view
.subckt sg13g2_nand4_1 Y A B C D VDD VSS
.ends

* Black-box entry subcircuit for sg13g2_fill_2 abstract view
.subckt sg13g2_fill_2 VDD VSS
.ends

* Black-box entry subcircuit for sg13g2_fill_1 abstract view
.subckt sg13g2_fill_1 VDD VSS
.ends

* Black-box entry subcircuit for sg13g2_buf_16 abstract view
.subckt sg13g2_buf_16 X A VDD VSS
.ends

* Black-box entry subcircuit for sg13g2_buf_1 abstract view
.subckt sg13g2_buf_1 X A VDD VSS
.ends

* Black-box entry subcircuit for sg13g2_decap_4 abstract view
.subckt sg13g2_decap_4 VDD VSS
.ends

* Black-box entry subcircuit for sg13g2_nand3b_1 abstract view
.subckt sg13g2_nand3b_1 Y A_N B C VDD VSS
.ends

* Black-box entry subcircuit for sg13g2_and2_1 abstract view
.subckt sg13g2_and2_1 X A B VDD VSS
.ends

* Black-box entry subcircuit for sg13g2_nor2_1 abstract view
.subckt sg13g2_nor2_1 Y A B VDD VSS
.ends

* Black-box entry subcircuit for sg13g2_buf_8 abstract view
.subckt sg13g2_buf_8 X A VDD VSS
.ends

* Black-box entry subcircuit for sg13g2_nand2b_1 abstract view
.subckt sg13g2_nand2b_1 Y A_N B VDD VSS
.ends

* Black-box entry subcircuit for sg13g2_a21oi_1 abstract view
.subckt sg13g2_a21oi_1 Y A1 A2 B1 VDD VSS
.ends

* Black-box entry subcircuit for sg13g2_nor2b_1 abstract view
.subckt sg13g2_nor2b_1 Y A B_N VDD VSS
.ends

* Black-box entry subcircuit for sg13g2_xnor2_1 abstract view
.subckt sg13g2_xnor2_1 Y A B VDD VSS
.ends

* Black-box entry subcircuit for delay_line abstract view
.subckt delay_line VDD VSS clk clk_delayed reset sel[0] sel[1] sel[2] sel[3] trim[0]
+ trim[10] trim[11] trim[12] trim[13] trim[14] trim[15] trim[16] trim[17] trim[18]
+ trim[19] trim[1] trim[20] trim[21] trim[22] trim[23] trim[2] trim[3] trim[4] trim[5]
+ trim[6] trim[7] trim[8] trim[9]
.ends

* Black-box entry subcircuit for sg13g2_dlygate4sd3_1 abstract view
.subckt sg13g2_dlygate4sd3_1 X A VDD VSS
.ends

* Black-box entry subcircuit for sg13g2_inv_2 abstract view
.subckt sg13g2_inv_2 Y A VDD VSS
.ends

* Black-box entry subcircuit for sg13g2_nand2_1 abstract view
.subckt sg13g2_nand2_1 Y A B VDD VSS
.ends

* Black-box entry subcircuit for sg13g2_inv_1 abstract view
.subckt sg13g2_inv_1 Y A VDD VSS
.ends

* Black-box entry subcircuit for sg13g2_inv_4 abstract view
.subckt sg13g2_inv_4 Y A VDD VSS
.ends

* Black-box entry subcircuit for sg13g2_xor2_1 abstract view
.subckt sg13g2_xor2_1 X A B VDD VSS
.ends

* Black-box entry subcircuit for sg13g2_nor3_1 abstract view
.subckt sg13g2_nor3_1 Y A B C VDD VSS
.ends

* Black-box entry subcircuit for sg13g2_nand3_1 abstract view
.subckt sg13g2_nand3_1 Y A B C VDD VSS
.ends

* Black-box entry subcircuit for sg13g2_o21ai_1 abstract view
.subckt sg13g2_o21ai_1 Y A1 A2 B1 VDD VSS
.ends

* Black-box entry subcircuit for sg13g2_a22oi_1 abstract view
.subckt sg13g2_a22oi_1 Y A1 A2 B1 B2 VDD VSS
.ends

* Black-box entry subcircuit for sg13g2_or2_1 abstract view
.subckt sg13g2_or2_1 X A B VDD VSS
.ends

* Black-box entry subcircuit for sg13g2_mux4_1 abstract view
.subckt sg13g2_mux4_1 X A0 A1 A2 A3 S0 S1 VDD VSS
.ends

* Black-box entry subcircuit for multimode_dll abstract view
.subckt multimode_dll VDD VSS bias clk0_out clk0_phase_sel[0] clk0_phase_sel[1] clk0_phase_sel[2]
+ clk0_phase_sel[3] clk0_phase_sel[4] clk1_out clk1_phase_sel[0] clk1_phase_sel[1]
+ clk1_phase_sel[2] clk1_phase_sel[3] clk1_phase_sel[4] clk2_out clk2_phase_sel[0]
+ clk2_phase_sel[1] clk2_phase_sel[2] clk2_phase_sel[3] clk2_phase_sel[4] dco enable
+ ext_trim[0] ext_trim[10] ext_trim[11] ext_trim[12] ext_trim[13] ext_trim[14] ext_trim[15]
+ ext_trim[16] ext_trim[17] ext_trim[18] ext_trim[19] ext_trim[1] ext_trim[20] ext_trim[21]
+ ext_trim[22] ext_trim[23] ext_trim[24] ext_trim[25] ext_trim[2] ext_trim[3] ext_trim[4]
+ ext_trim[5] ext_trim[6] ext_trim[7] ext_trim[8] ext_trim[9] f_clk0_divider[0] f_clk0_divider[1]
+ f_clk0_divider[2] f_clk0_divider[3] f_clk0_divider[4] f_clk1_divider[0] f_clk1_divider[1]
+ f_clk1_divider[2] f_clk1_divider[3] f_clk1_divider[4] f_clk2_divider[0] f_clk2_divider[1]
+ f_clk2_divider[2] f_clk2_divider[3] f_clk2_divider[4] f_osc_multiply_factor[0] f_osc_multiply_factor[1]
+ f_osc_multiply_factor[2] f_osc_multiply_factor[3] f_osc_multiply_factor[4] mode_xor[0]
+ mode_xor[1] mode_xor[2] osc osc_out resetb stable
.ends

* Black-box entry subcircuit for SwitchMatrixMultiplexer_inv abstract view
.subckt SwitchMatrixMultiplexer_inv D A VDD B X VSS SEL
.ends

* Black-box entry subcircuit for mux_inv abstract view
.subckt mux_inv X VDD VSS SEL B A
.ends

* Black-box entry subcircuit for latch abstract view
.subckt latch Q D VSS VDD GATE
.ends

* Black-box entry subcircuit for sg13g2_a21o_1 abstract view
.subckt sg13g2_a21o_1 X A1 A2 B1 VDD VSS
.ends

* Black-box entry subcircuit for sg13g2_antennanp abstract view
.subckt sg13g2_antennanp A VDD VSS
.ends

* Black-box entry subcircuit for mux abstract view
.subckt mux VSS VDD X A SEL B
.ends

* Black-box entry subcircuit for SwitchMatrixMultiplexer abstract view
.subckt SwitchMatrixMultiplexer D VSS VDD A B X SEL
.ends

.subckt heichips25_internal VGND VPWR analog_pin0 analog_pin1 analog_pin2 clk ena
+ rst_n ui_in[0] ui_in[1] ui_in[2] ui_in[3] ui_in[4] ui_in[5] ui_in[6] ui_in[7] uio_in[0]
+ uio_in[1] uio_in[2] uio_in[3] uio_in[4] uio_in[5] uio_in[6] uio_in[7] uio_oe[0]
+ uio_oe[1] uio_oe[2] uio_oe[3] uio_oe[4] uio_oe[5] uio_oe[6] uio_oe[7] uio_out[0]
+ uio_out[1] uio_out[2] uio_out[3] uio_out[4] uio_out[5] uio_out[6] uio_out[7] uo_out[0]
+ uo_out[1] uo_out[2] uo_out[3] uo_out[4] uo_out[5] uo_out[6] uo_out[7]
XFILLER_11_1020 VPWR VGND sg13g2_decap_8
XFILLER_2_527 VPWR VGND sg13g2_decap_8
XFILLER_46_704 VPWR VGND sg13g2_decap_8
XFILLER_45_236 VPWR VGND sg13g2_decap_8
X_501_ _501_/Q _506_/CLK _501_/D fanout87/X VPWR VGND sg13g2_dfrbpq_1
X_432_ _597_/D _596_/Q _626_/D _436_/S VPWR VGND sg13g2_mux2_1
XFILLER_10_851 VPWR VGND sg13g2_decap_8
X_363_ _528_/D _527_/Q _528_/Q _369_/S VPWR VGND sg13g2_mux2_1
X_294_ _295_/B _469_/Q _471_/Q _472_/Q _475_/Q VPWR VGND sg13g2_nand4_1
XFILLER_6_833 VPWR VGND sg13g2_decap_8
XFILLER_5_321 VPWR VGND sg13g2_decap_8
XFILLER_49_597 VPWR VGND sg13g2_decap_8
XFILLER_49_520 VPWR VGND sg13g2_decap_8
XFILLER_44_291 VPWR VGND sg13g2_decap_8
XFILLER_36_770 VPWR VGND sg13g2_decap_8
XFILLER_43_707 VPWR VGND sg13g2_decap_8
XFILLER_3_847 VPWR VGND sg13g2_decap_8
XFILLER_46_556 VPWR VGND sg13g2_decap_8
XFILLER_15_954 VPWR VGND sg13g2_fill_2
XFILLER_27_770 VPWR VGND sg13g2_decap_8
XFILLER_42_740 VPWR VGND sg13g2_decap_8
X_415_ _580_/D _579_/Q _607_/D _415_/S VPWR VGND sg13g2_mux2_1
X_346_ _511_/D _510_/Q _511_/Q _348_/S VPWR VGND sg13g2_mux2_1
X_277_ _633_/D _611_/Q _625_/Q _277_/S VPWR VGND sg13g2_mux2_1
XFILLER_2_891 VPWR VGND sg13g2_decap_8
XFILLER_49_394 VPWR VGND sg13g2_decap_8
XFILLER_33_784 VPWR VGND sg13g2_decap_8
XFILLER_33_795 VPWR VGND sg13g2_fill_1
XFILLER_12_935 VPWR VGND sg13g2_decap_8
XFILLER_24_784 VPWR VGND sg13g2_decap_8
Xclkbuf_5_14__f_clk_regs _521_/CLK clkbuf_4_7_0_clk_regs/X VPWR VGND sg13g2_buf_16
XFILLER_7_427 VPWR VGND sg13g2_decap_8
XFILLER_2_165 VPWR VGND sg13g2_fill_1
XFILLER_3_644 VPWR VGND sg13g2_decap_8
XFILLER_46_353 VPWR VGND sg13g2_decap_8
XFILLER_47_898 VPWR VGND sg13g2_decap_8
XFILLER_47_821 VPWR VGND sg13g2_decap_8
X_329_ _494_/D _493_/Q _494_/Q _407_/S VPWR VGND sg13g2_mux2_1
XFILLER_7_983 VPWR VGND sg13g2_decap_8
XFILLER_21_798 VPWR VGND sg13g2_decap_8
XFILLER_0_669 VPWR VGND sg13g2_decap_8
XFILLER_48_607 VPWR VGND sg13g2_decap_8
XFILLER_29_810 VPWR VGND sg13g2_decap_8
XFILLER_8_769 VPWR VGND sg13g2_decap_8
XFILLER_4_953 VPWR VGND sg13g2_decap_8
XFILLER_47_695 VPWR VGND sg13g2_decap_8
XFILLER_7_780 VPWR VGND sg13g2_decap_8
XFILLER_26_802 VPWR VGND sg13g2_decap_8
XFILLER_1_912 VPWR VGND sg13g2_decap_8
XFILLER_0_466 VPWR VGND sg13g2_fill_1
XFILLER_1_989 VPWR VGND sg13g2_decap_8
XFILLER_49_949 VPWR VGND sg13g2_fill_1
XFILLER_49_905 VPWR VGND sg13g2_decap_8
XFILLER_48_404 VPWR VGND sg13g2_decap_8
XFILLER_17_835 VPWR VGND sg13g2_fill_1
XFILLER_44_654 VPWR VGND sg13g2_decap_8
X_594_ _623_/D _608_/CLK _594_/D fanout73/X VPWR VGND sg13g2_dfrbpq_1
XFILLER_4_750 VPWR VGND sg13g2_decap_8
XFILLER_47_492 VPWR VGND sg13g2_decap_8
XFILLER_2_709 VPWR VGND sg13g2_decap_8
Xdelaybuf_10_clk delaybuf_11_clk/A delaybuf_9_clk/X VPWR VGND sg13g2_buf_16
XFILLER_14_827 VPWR VGND sg13g2_decap_8
XFILLER_45_429 VPWR VGND sg13g2_decap_8
XFILLER_41_668 VPWR VGND sg13g2_decap_8
XFILLER_5_503 VPWR VGND sg13g2_fill_2
Xoutput31 uo_out[1] _283_/Y VPWR VGND sg13g2_buf_1
Xoutput20 uio_oe[6] _255_/X VPWR VGND sg13g2_buf_1
XFILLER_0_263 VPWR VGND sg13g2_fill_2
XFILLER_1_786 VPWR VGND sg13g2_decap_8
Xclkbuf_2_0__f_clk_delayed _459_/A clkbuf_0_clk_delayed/X VPWR VGND sg13g2_buf_16
XFILLER_49_779 VPWR VGND sg13g2_decap_8
XFILLER_49_702 VPWR VGND sg13g2_decap_8
XFILLER_48_278 VPWR VGND sg13g2_decap_8
XFILLER_48_245 VPWR VGND sg13g2_fill_2
XFILLER_44_495 VPWR VGND sg13g2_decap_4
X_577_ _577_/Q _578_/CLK _577_/D fanout88/X VPWR VGND sg13g2_dfrbpq_1
X_646_ _646_/Q _460_/Y _647_/D fanout77/X VPWR VGND sg13g2_dfrbpq_1
XFILLER_13_882 VPWR VGND sg13g2_decap_8
XFILLER_9_875 VPWR VGND sg13g2_decap_8
XFILLER_11_0 VPWR VGND sg13g2_fill_2
X_500_ _500_/Q _513_/CLK _500_/D fanout86/X VPWR VGND sg13g2_dfrbpq_1
XFILLER_41_432 VPWR VGND sg13g2_fill_2
X_431_ _596_/D _624_/D _596_/Q _431_/S VPWR VGND sg13g2_mux2_1
X_362_ _527_/D _526_/Q _527_/Q _431_/S VPWR VGND sg13g2_mux2_1
XFILLER_10_830 VPWR VGND sg13g2_decap_8
XFILLER_41_498 VPWR VGND sg13g2_decap_4
X_293_ _295_/A _470_/Q _473_/Q _474_/Q VPWR VGND sg13g2_nand3b_1
XFILLER_6_812 VPWR VGND sg13g2_decap_8
XFILLER_1_583 VPWR VGND sg13g2_decap_8
XFILLER_6_889 VPWR VGND sg13g2_decap_8
XFILLER_37_749 VPWR VGND sg13g2_decap_8
XFILLER_3_1008 VPWR VGND sg13g2_decap_8
X_629_ _629_/Q _629_/CLK _629_/D fanout66/X VPWR VGND sg13g2_dfrbpq_1
XFILLER_49_576 VPWR VGND sg13g2_decap_8
XFILLER_44_270 VPWR VGND sg13g2_fill_1
XFILLER_45_793 VPWR VGND sg13g2_decap_8
XFILLER_28_749 VPWR VGND sg13g2_decap_8
Xclkbuf_5_13__f_clk_regs _488_/CLK clkbuf_4_6_0_clk_regs/X VPWR VGND sg13g2_buf_16
XFILLER_12_11 VPWR VGND sg13g2_fill_2
XFILLER_3_826 VPWR VGND sg13g2_decap_8
XFILLER_46_535 VPWR VGND sg13g2_decap_8
XFILLER_42_796 VPWR VGND sg13g2_decap_8
X_414_ _579_/D _578_/Q _579_/Q _415_/S VPWR VGND sg13g2_mux2_1
X_345_ _510_/D _509_/Q _510_/Q _415_/S VPWR VGND sg13g2_mux2_1
X_276_ _632_/D _610_/Q _624_/Q _278_/S VPWR VGND sg13g2_mux2_1
XFILLER_6_675 VPWR VGND sg13g2_decap_8
XFILLER_5_141 VPWR VGND sg13g2_fill_1
XFILLER_2_870 VPWR VGND sg13g2_decap_8
XFILLER_49_373 VPWR VGND sg13g2_decap_8
XFILLER_33_763 VPWR VGND sg13g2_decap_8
XFILLER_45_590 VPWR VGND sg13g2_decap_8
XFILLER_12_914 VPWR VGND sg13g2_decap_8
XFILLER_24_763 VPWR VGND sg13g2_decap_8
XFILLER_7_406 VPWR VGND sg13g2_decap_8
XFILLER_3_623 VPWR VGND sg13g2_decap_8
XFILLER_47_800 VPWR VGND sg13g2_decap_8
XFILLER_0_36 VPWR VGND sg13g2_fill_2
XFILLER_30_777 VPWR VGND sg13g2_decap_8
XFILLER_42_593 VPWR VGND sg13g2_decap_8
X_328_ _493_/D _492_/Q _493_/Q _407_/S VPWR VGND sg13g2_mux2_1
X_259_ _259_/X _259_/A _259_/B VPWR VGND sg13g2_and2_1
XFILLER_7_962 VPWR VGND sg13g2_decap_8
XFILLER_9_1003 VPWR VGND sg13g2_fill_1
XFILLER_38_833 VPWR VGND sg13g2_decap_8
XFILLER_21_777 VPWR VGND sg13g2_decap_8
XFILLER_0_648 VPWR VGND sg13g2_decap_8
XFILLER_44_836 VPWR VGND sg13g2_decap_8
XFILLER_12_788 VPWR VGND sg13g2_decap_8
XFILLER_15_1008 VPWR VGND sg13g2_decap_8
XFILLER_43_379 VPWR VGND sg13g2_decap_8
XFILLER_4_932 VPWR VGND sg13g2_decap_8
XFILLER_47_674 VPWR VGND sg13g2_decap_8
XFILLER_0_445 VPWR VGND sg13g2_decap_8
XFILLER_1_968 VPWR VGND sg13g2_decap_8
XFILLER_44_633 VPWR VGND sg13g2_decap_8
X_593_ _593_/Q _621_/CLK _593_/D fanout73/X VPWR VGND sg13g2_dfrbpq_1
XFILLER_6_68 VPWR VGND sg13g2_fill_1
XFILLER_48_950 VPWR VGND sg13g2_decap_8
XFILLER_47_471 VPWR VGND sg13g2_decap_8
XFILLER_45_408 VPWR VGND sg13g2_decap_8
XFILLER_14_806 VPWR VGND sg13g2_decap_8
XFILLER_41_647 VPWR VGND sg13g2_decap_8
XFILLER_0_231 VPWR VGND sg13g2_decap_4
XFILLER_1_765 VPWR VGND sg13g2_decap_8
Xdelaybuf_3_clk delaybuf_4_clk/A delaybuf_3_clk/A VPWR VGND sg13g2_buf_16
Xoutput32 uo_out[2] _285_/Y VPWR VGND sg13g2_buf_1
Xoutput21 uio_oe[7] _258_/Y VPWR VGND sg13g2_buf_1
X_645_ _645_/Q _459_/Y _645_/D fanout76/X VPWR VGND sg13g2_dfrbpq_1
XFILLER_49_758 VPWR VGND sg13g2_decap_8
XFILLER_13_861 VPWR VGND sg13g2_decap_8
XFILLER_20_809 VPWR VGND sg13g2_decap_8
XFILLER_44_474 VPWR VGND sg13g2_decap_8
X_576_ _576_/Q _578_/CLK _576_/D fanout85/X VPWR VGND sg13g2_dfrbpq_1
XFILLER_9_854 VPWR VGND sg13g2_decap_8
Xclkbuf_5_12__f_clk_regs _657_/CLK clkbuf_4_6_0_clk_regs/X VPWR VGND sg13g2_buf_16
XFILLER_39_791 VPWR VGND sg13g2_decap_8
XFILLER_46_739 VPWR VGND sg13g2_decap_8
XFILLER_41_444 VPWR VGND sg13g2_fill_2
X_430_ _595_/D _623_/D _624_/D _435_/S VPWR VGND sg13g2_mux2_1
X_361_ _526_/D _525_/Q _526_/Q _431_/S VPWR VGND sg13g2_mux2_1
X_292_ _307_/A _473_/Q _474_/Q VPWR VGND sg13g2_and2_1
XFILLER_10_886 VPWR VGND sg13g2_decap_8
XFILLER_6_868 VPWR VGND sg13g2_decap_8
XFILLER_1_562 VPWR VGND sg13g2_decap_8
XFILLER_3_14 VPWR VGND sg13g2_fill_1
XFILLER_49_555 VPWR VGND sg13g2_decap_8
XFILLER_45_772 VPWR VGND sg13g2_decap_8
X_628_ _628_/Q _629_/CLK _628_/D fanout65/X VPWR VGND sg13g2_dfrbpq_1
X_559_ _559_/Q _560_/CLK _559_/D fanout92/X VPWR VGND sg13g2_dfrbpq_1
XFILLER_3_805 VPWR VGND sg13g2_decap_8
XFILLER_15_912 VPWR VGND sg13g2_decap_8
X_413_ _578_/D _577_/Q _578_/Q _413_/S VPWR VGND sg13g2_mux2_1
XFILLER_46_514 VPWR VGND sg13g2_decap_8
XFILLER_15_956 VPWR VGND sg13g2_fill_1
XFILLER_42_775 VPWR VGND sg13g2_decap_8
X_344_ _509_/D _508_/Q _509_/Q _415_/S VPWR VGND sg13g2_mux2_1
X_275_ _631_/D _609_/Q _623_/Q _278_/S VPWR VGND sg13g2_mux2_1
XFILLER_6_654 VPWR VGND sg13g2_decap_8
XFILLER_49_352 VPWR VGND sg13g2_decap_8
XFILLER_18_783 VPWR VGND sg13g2_decap_8
XFILLER_43_539 VPWR VGND sg13g2_decap_8
XFILLER_3_602 VPWR VGND sg13g2_decap_8
XFILLER_3_679 VPWR VGND sg13g2_decap_8
XFILLER_15_797 VPWR VGND sg13g2_decap_8
XFILLER_42_572 VPWR VGND sg13g2_decap_8
XFILLER_46_388 VPWR VGND sg13g2_decap_8
XFILLER_11_992 VPWR VGND sg13g2_decap_8
XFILLER_30_756 VPWR VGND sg13g2_decap_8
X_327_ _492_/D _491_/Q _492_/Q _410_/S VPWR VGND sg13g2_mux2_1
X_258_ _258_/Y _258_/A _258_/B VPWR VGND sg13g2_nor2_1
XFILLER_7_941 VPWR VGND sg13g2_decap_8
XFILLER_38_812 VPWR VGND sg13g2_decap_8
Xclkbuf_4_9_0_clk_regs clkbuf_4_9_0_clk_regs/X clkbuf_0_clk_regs/X VPWR VGND sg13g2_buf_8
XFILLER_21_756 VPWR VGND sg13g2_decap_8
XFILLER_0_627 VPWR VGND sg13g2_decap_8
XFILLER_44_815 VPWR VGND sg13g2_decap_8
XFILLER_7_226 VPWR VGND sg13g2_decap_8
XFILLER_4_911 VPWR VGND sg13g2_decap_8
XFILLER_4_988 VPWR VGND sg13g2_decap_8
XFILLER_47_653 VPWR VGND sg13g2_decap_8
XFILLER_26_837 VPWR VGND sg13g2_decap_8
XFILLER_41_829 VPWR VGND sg13g2_decap_8
XFILLER_1_947 VPWR VGND sg13g2_decap_8
XFILLER_17_826 VPWR VGND sg13g2_decap_8
XFILLER_44_612 VPWR VGND sg13g2_decap_8
X_592_ _592_/Q _621_/CLK _592_/D fanout71/X VPWR VGND sg13g2_dfrbpq_1
XFILLER_48_439 VPWR VGND sg13g2_decap_8
XFILLER_40_840 VPWR VGND sg13g2_decap_8
XFILLER_40_851 VPWR VGND sg13g2_fill_1
XFILLER_44_689 VPWR VGND sg13g2_decap_8
XFILLER_0_991 VPWR VGND sg13g2_decap_8
XFILLER_3_262 VPWR VGND sg13g2_fill_1
Xclkbuf_5_11__f_clk_regs _652_/CLK clkbuf_4_5_0_clk_regs/X VPWR VGND sg13g2_buf_16
XFILLER_4_785 VPWR VGND sg13g2_decap_8
XFILLER_47_450 VPWR VGND sg13g2_decap_8
XFILLER_16_881 VPWR VGND sg13g2_fill_1
XFILLER_31_851 VPWR VGND sg13g2_fill_1
XFILLER_15_34 VPWR VGND sg13g2_fill_2
XFILLER_41_626 VPWR VGND sg13g2_decap_8
XFILLER_5_505 VPWR VGND sg13g2_fill_1
XFILLER_0_265 VPWR VGND sg13g2_fill_1
XFILLER_1_744 VPWR VGND sg13g2_decap_8
Xoutput33 uo_out[3] _287_/Y VPWR VGND sg13g2_buf_1
Xoutput22 uio_out[0] _242_/X VPWR VGND sg13g2_buf_1
XFILLER_49_737 VPWR VGND sg13g2_decap_8
XFILLER_44_453 VPWR VGND sg13g2_decap_8
X_575_ _575_/Q _575_/CLK _575_/D fanout86/X VPWR VGND sg13g2_dfrbpq_1
X_644_ _644_/Q _458_/Y _644_/D fanout77/X VPWR VGND sg13g2_dfrbpq_1
XFILLER_13_840 VPWR VGND sg13g2_decap_8
XFILLER_9_833 VPWR VGND sg13g2_decap_8
XFILLER_4_582 VPWR VGND sg13g2_decap_8
XFILLER_11_2 VPWR VGND sg13g2_fill_1
XFILLER_47_291 VPWR VGND sg13g2_decap_8
XFILLER_39_770 VPWR VGND sg13g2_decap_8
XFILLER_46_718 VPWR VGND sg13g2_decap_8
X_360_ _525_/D _524_/Q _525_/Q _431_/S VPWR VGND sg13g2_mux2_1
X_291_ _291_/Y _602_/Q _291_/B VPWR VGND sg13g2_nand2b_1
XFILLER_10_865 VPWR VGND sg13g2_decap_8
Xclkbuf_4_11_0_clk_regs clkbuf_4_11_0_clk_regs/X clkbuf_0_clk_regs/X VPWR VGND sg13g2_buf_8
XFILLER_6_847 VPWR VGND sg13g2_decap_8
XFILLER_5_335 VPWR VGND sg13g2_decap_8
XFILLER_1_541 VPWR VGND sg13g2_decap_8
XFILLER_49_534 VPWR VGND sg13g2_decap_8
XFILLER_44_261 VPWR VGND sg13g2_decap_8
XFILLER_45_751 VPWR VGND sg13g2_decap_8
X_558_ _558_/Q _560_/CLK _558_/D fanout92/X VPWR VGND sg13g2_dfrbpq_1
X_627_ _627_/Q _627_/CLK _627_/D fanout64/X VPWR VGND sg13g2_dfrbpq_1
X_489_ _489_/Q _506_/CLK _489_/D fanout87/X VPWR VGND sg13g2_dfrbpq_1
XFILLER_5_891 VPWR VGND sg13g2_decap_8
XFILLER_36_784 VPWR VGND sg13g2_decap_8
XFILLER_27_784 VPWR VGND sg13g2_decap_8
XFILLER_2_1010 VPWR VGND sg13g2_decap_8
XFILLER_42_754 VPWR VGND sg13g2_decap_8
X_412_ _577_/D _576_/Q _577_/Q _413_/S VPWR VGND sg13g2_mux2_1
X_343_ _508_/D _507_/Q _508_/Q _429_/S VPWR VGND sg13g2_mux2_1
X_274_ _638_/D _616_/Q _630_/Q _278_/S VPWR VGND sg13g2_mux2_1
XFILLER_6_633 VPWR VGND sg13g2_decap_8
XFILLER_5_176 VPWR VGND sg13g2_decap_4
XFILLER_18_762 VPWR VGND sg13g2_decap_8
XFILLER_49_331 VPWR VGND sg13g2_decap_8
XFILLER_0_809 VPWR VGND sg13g2_decap_8
XFILLER_12_949 VPWR VGND sg13g2_decap_8
XFILLER_24_798 VPWR VGND sg13g2_fill_2
XFILLER_8_909 VPWR VGND sg13g2_decap_8
XFILLER_3_658 VPWR VGND sg13g2_decap_8
XFILLER_0_38 VPWR VGND sg13g2_fill_1
XFILLER_46_301 VPWR VGND sg13g2_fill_2
XFILLER_46_367 VPWR VGND sg13g2_decap_8
XFILLER_47_835 VPWR VGND sg13g2_decap_8
XFILLER_15_776 VPWR VGND sg13g2_decap_8
XFILLER_42_551 VPWR VGND sg13g2_decap_8
X_326_ _491_/D _490_/Q _491_/Q _410_/S VPWR VGND sg13g2_mux2_1
XFILLER_9_47 VPWR VGND sg13g2_fill_2
XFILLER_11_971 VPWR VGND sg13g2_decap_8
Xfanout90 fanout90/X fanout91/X VPWR VGND sg13g2_buf_1
XFILLER_7_997 VPWR VGND sg13g2_decap_4
XFILLER_7_920 VPWR VGND sg13g2_decap_8
XFILLER_0_606 VPWR VGND sg13g2_decap_8
XFILLER_29_824 VPWR VGND sg13g2_fill_1
XFILLER_3_422 VPWR VGND sg13g2_decap_8
XFILLER_3_466 VPWR VGND sg13g2_fill_1
XFILLER_3_477 VPWR VGND sg13g2_decap_4
XFILLER_3_499 VPWR VGND sg13g2_fill_2
Xclkbuf_5_10__f_clk_regs _660_/CLK clkbuf_4_5_0_clk_regs/X VPWR VGND sg13g2_buf_16
XFILLER_4_967 VPWR VGND sg13g2_decap_8
XFILLER_35_805 VPWR VGND sg13g2_decap_8
XFILLER_47_632 VPWR VGND sg13g2_decap_8
X_309_ _474_/D _307_/A _307_/B _308_/Y VPWR VGND sg13g2_a21oi_1
XFILLER_7_794 VPWR VGND sg13g2_decap_8
Xclkbuf_5_29__f_clk_regs _570_/CLK clkbuf_4_14_0_clk_regs/X VPWR VGND sg13g2_buf_16
Xdelaybuf_22_clk delaybuf_22_clk/X delaybuf_22_clk/A VPWR VGND sg13g2_buf_16
XFILLER_26_816 VPWR VGND sg13g2_decap_8
XFILLER_41_808 VPWR VGND sg13g2_decap_8
XFILLER_1_926 VPWR VGND sg13g2_decap_8
Xdelaybuf_13_clk delaybuf_14_clk/A delaybuf_13_clk/A VPWR VGND sg13g2_buf_16
XFILLER_49_919 VPWR VGND sg13g2_decap_8
XFILLER_48_418 VPWR VGND sg13g2_decap_8
XFILLER_17_805 VPWR VGND sg13g2_decap_8
X_591_ _591_/Q _621_/CLK _591_/D fanout71/X VPWR VGND sg13g2_dfrbpq_1
X_660_ _660_/Q _660_/CLK _660_/D fanout80/X VPWR VGND sg13g2_dfrbpq_1
XFILLER_44_668 VPWR VGND sg13g2_decap_8
XFILLER_4_764 VPWR VGND sg13g2_decap_8
XFILLER_0_970 VPWR VGND sg13g2_decap_8
XFILLER_6_1008 VPWR VGND sg13g2_decap_8
XFILLER_48_985 VPWR VGND sg13g2_fill_2
XFILLER_41_605 VPWR VGND sg13g2_decap_8
Xoutput34 uo_out[4] _289_/Y VPWR VGND sg13g2_buf_1
Xoutput23 uio_out[1] _243_/X VPWR VGND sg13g2_buf_1
XFILLER_0_200 VPWR VGND sg13g2_decap_4
XFILLER_1_723 VPWR VGND sg13g2_decap_8
XFILLER_49_716 VPWR VGND sg13g2_decap_8
XFILLER_44_432 VPWR VGND sg13g2_decap_8
X_574_ _574_/Q _574_/CLK _574_/D fanout88/X VPWR VGND sg13g2_dfrbpq_1
X_643_ _643_/Q _457_/Y _643_/D fanout77/X VPWR VGND sg13g2_dfrbpq_1
XFILLER_13_896 VPWR VGND sg13g2_decap_8
XFILLER_9_889 VPWR VGND sg13g2_decap_8
XFILLER_9_812 VPWR VGND sg13g2_decap_8
XFILLER_4_561 VPWR VGND sg13g2_decap_8
XFILLER_48_782 VPWR VGND sg13g2_decap_8
XFILLER_47_270 VPWR VGND sg13g2_decap_8
XFILLER_11_1013 VPWR VGND sg13g2_decap_8
XFILLER_10_844 VPWR VGND sg13g2_decap_8
XFILLER_42_44 VPWR VGND sg13g2_fill_1
X_290_ _311_/S _602_/Q _291_/B VPWR VGND sg13g2_nor2b_1
XFILLER_6_826 VPWR VGND sg13g2_decap_8
XFILLER_5_314 VPWR VGND sg13g2_fill_2
XFILLER_1_597 VPWR VGND sg13g2_decap_8
XFILLER_45_730 VPWR VGND sg13g2_decap_8
XFILLER_49_513 VPWR VGND sg13g2_decap_8
XFILLER_44_240 VPWR VGND sg13g2_decap_8
XFILLER_44_284 VPWR VGND sg13g2_decap_8
X_557_ _557_/Q _569_/CLK _557_/D fanout96/X VPWR VGND sg13g2_dfrbpq_1
X_626_ _626_/Q _627_/CLK _626_/D fanout67/X VPWR VGND sg13g2_dfrbpq_1
X_488_ _488_/Q _488_/CLK _488_/D fanout89/X VPWR VGND sg13g2_dfrbpq_1
XFILLER_5_870 VPWR VGND sg13g2_decap_8
XFILLER_4_391 VPWR VGND sg13g2_fill_2
XFILLER_36_763 VPWR VGND sg13g2_decap_8
XFILLER_46_549 VPWR VGND sg13g2_decap_8
XFILLER_27_763 VPWR VGND sg13g2_decap_8
XFILLER_42_733 VPWR VGND sg13g2_decap_8
X_411_ _576_/D _575_/Q _576_/Q _413_/S VPWR VGND sg13g2_mux2_1
X_342_ _507_/D _506_/Q _507_/Q _429_/S VPWR VGND sg13g2_mux2_1
XFILLER_41_298 VPWR VGND sg13g2_fill_2
X_273_ _637_/D _615_/Q _629_/Q _278_/S VPWR VGND sg13g2_mux2_1
XFILLER_6_612 VPWR VGND sg13g2_decap_8
XFILLER_1_394 VPWR VGND sg13g2_fill_1
XFILLER_2_884 VPWR VGND sg13g2_decap_8
XFILLER_6_689 VPWR VGND sg13g2_fill_2
XFILLER_49_310 VPWR VGND sg13g2_decap_8
X_609_ _609_/Q _609_/CLK _609_/D fanout65/X VPWR VGND sg13g2_dfrbpq_1
XFILLER_49_387 VPWR VGND sg13g2_decap_8
XFILLER_33_777 VPWR VGND sg13g2_decap_8
XFILLER_12_928 VPWR VGND sg13g2_decap_8
XFILLER_24_777 VPWR VGND sg13g2_decap_8
XFILLER_3_637 VPWR VGND sg13g2_decap_8
XFILLER_46_346 VPWR VGND sg13g2_decap_8
XFILLER_47_814 VPWR VGND sg13g2_decap_8
XFILLER_11_950 VPWR VGND sg13g2_decap_8
Xfanout91 fanout91/X fanout97/X VPWR VGND sg13g2_buf_1
Xfanout80 fanout80/X fanout83/X VPWR VGND sg13g2_buf_1
X_325_ _490_/D _489_/Q _490_/Q _348_/S VPWR VGND sg13g2_mux2_1
X_256_ _256_/Y _459_/A _256_/B VPWR VGND sg13g2_xnor2_1
XFILLER_7_976 VPWR VGND sg13g2_decap_8
XFILLER_2_681 VPWR VGND sg13g2_decap_8
XFILLER_38_847 VPWR VGND sg13g2_decap_4
Xclkbuf_5_28__f_clk_regs _574_/CLK clkbuf_4_14_0_clk_regs/X VPWR VGND sg13g2_buf_16
Xclkbuf_leaf_1_clk _256_/B clkload0/A VPWR VGND sg13g2_buf_8
XFILLER_47_1012 VPWR VGND sg13g2_decap_8
XFILLER_29_803 VPWR VGND sg13g2_decap_8
Xu_delay_line VPWR VGND u_delay_line/clk clkbuf_0_clk_delayed/A fanout93/X _566_/Q
+ _567_/Q _568_/Q _569_/Q _542_/Q _552_/Q _553_/Q _554_/Q _555_/Q _556_/Q _557_/Q
+ _558_/Q _559_/Q _560_/Q _561_/Q _543_/Q _562_/Q _563_/Q _564_/Q _565_/Q _544_/Q
+ _545_/Q _546_/Q _547_/Q _548_/Q _549_/Q _550_/Q _551_/Q delay_line
Xclkload0 clkload0/X clkload0/A VPWR VGND sg13g2_buf_8
XFILLER_4_946 VPWR VGND sg13g2_decap_8
XFILLER_47_611 VPWR VGND sg13g2_decap_8
XFILLER_47_688 VPWR VGND sg13g2_decap_8
X_308_ _308_/Y _473_/Q _307_/B _474_/Q VPWR VGND sg13g2_a21oi_1
X_239_ _239_/X _654_/Q _253_/B VPWR VGND sg13g2_and2_1
XFILLER_7_773 VPWR VGND sg13g2_decap_8
XFILLER_0_459 VPWR VGND sg13g2_decap_8
XFILLER_1_905 VPWR VGND sg13g2_decap_8
XFILLER_25_850 VPWR VGND sg13g2_fill_2
XFILLER_44_647 VPWR VGND sg13g2_decap_8
X_590_ _590_/Q _620_/CLK _590_/D fanout73/X VPWR VGND sg13g2_dfrbpq_1
Xdelaybuf_6_clk delaybuf_7_clk/A delaybuf_6_clk/A VPWR VGND sg13g2_buf_16
XFILLER_4_743 VPWR VGND sg13g2_decap_8
XFILLER_16_850 VPWR VGND sg13g2_decap_8
XFILLER_16_861 VPWR VGND sg13g2_fill_2
XFILLER_47_485 VPWR VGND sg13g2_decap_8
XFILLER_22_831 VPWR VGND sg13g2_decap_8
XFILLER_1_702 VPWR VGND sg13g2_decap_8
Xoutput35 uo_out[5] _239_/X VPWR VGND sg13g2_buf_1
Xoutput24 uio_out[2] _244_/X VPWR VGND sg13g2_buf_1
XFILLER_1_779 VPWR VGND sg13g2_decap_8
X_642_ _642_/Q _456_/Y _642_/D fanout71/X VPWR VGND sg13g2_dfrbpq_1
XFILLER_48_238 VPWR VGND sg13g2_decap_8
XFILLER_44_411 VPWR VGND sg13g2_decap_8
XFILLER_44_488 VPWR VGND sg13g2_decap_8
XFILLER_44_499 VPWR VGND sg13g2_fill_1
X_573_ _573_/Q _574_/CLK _573_/D fanout86/X VPWR VGND sg13g2_dfrbpq_1
XFILLER_13_875 VPWR VGND sg13g2_decap_8
XFILLER_9_868 VPWR VGND sg13g2_decap_8
XFILLER_4_540 VPWR VGND sg13g2_decap_8
XFILLER_48_761 VPWR VGND sg13g2_decap_8
XFILLER_26_46 VPWR VGND sg13g2_fill_2
XFILLER_41_425 VPWR VGND sg13g2_decap_8
XFILLER_10_823 VPWR VGND sg13g2_decap_8
XFILLER_6_805 VPWR VGND sg13g2_decap_8
XFILLER_1_576 VPWR VGND sg13g2_decap_8
X_625_ _625_/Q _655_/CLK _625_/D fanout69/X VPWR VGND sg13g2_dfrbpq_1
XFILLER_49_569 VPWR VGND sg13g2_decap_8
XFILLER_45_786 VPWR VGND sg13g2_decap_8
X_556_ _556_/Q _568_/CLK _556_/D fanout95/X VPWR VGND sg13g2_dfrbpq_1
X_487_ _487_/Q _488_/CLK _487_/D fanout89/X VPWR VGND sg13g2_dfrbpq_1
XFILLER_3_819 VPWR VGND sg13g2_decap_8
Xhold120 _653_/D _465_/Q VPWR VGND sg13g2_dlygate4sd3_1
XFILLER_46_528 VPWR VGND sg13g2_decap_8
XFILLER_15_926 VPWR VGND sg13g2_fill_1
XFILLER_41_266 VPWR VGND sg13g2_decap_4
XFILLER_42_712 VPWR VGND sg13g2_decap_8
XFILLER_42_789 VPWR VGND sg13g2_decap_8
X_410_ _575_/D _574_/Q _575_/Q _410_/S VPWR VGND sg13g2_mux2_1
X_341_ _506_/D _505_/Q _506_/Q _413_/S VPWR VGND sg13g2_mux2_1
X_272_ _636_/D _614_/Q _628_/Q _278_/S VPWR VGND sg13g2_mux2_1
XFILLER_6_668 VPWR VGND sg13g2_decap_8
XFILLER_2_863 VPWR VGND sg13g2_decap_8
Xclkbuf_5_27__f_clk_regs _568_/CLK clkbuf_4_13_0_clk_regs/X VPWR VGND sg13g2_buf_16
XFILLER_49_366 VPWR VGND sg13g2_decap_8
XFILLER_18_797 VPWR VGND sg13g2_decap_8
XFILLER_33_756 VPWR VGND sg13g2_decap_8
XFILLER_45_583 VPWR VGND sg13g2_decap_8
X_608_ _608_/Q _608_/CLK _608_/D fanout73/X VPWR VGND sg13g2_dfrbpq_1
XFILLER_14_981 VPWR VGND sg13g2_decap_8
X_539_ _539_/Q _627_/CLK _539_/D fanout69/X VPWR VGND sg13g2_dfrbpq_1
XFILLER_5_690 VPWR VGND sg13g2_decap_8
XFILLER_12_907 VPWR VGND sg13g2_decap_8
XFILLER_24_756 VPWR VGND sg13g2_decap_8
XFILLER_3_616 VPWR VGND sg13g2_decap_8
XFILLER_42_586 VPWR VGND sg13g2_decap_8
Xfanout70 fanout70/X fanout74/X VPWR VGND sg13g2_buf_1
Xfanout92 fanout92/X fanout93/X VPWR VGND sg13g2_buf_1
Xfanout81 fanout81/X fanout82/X VPWR VGND sg13g2_buf_1
X_324_ _489_/D _488_/Q _489_/Q _415_/S VPWR VGND sg13g2_mux2_1
X_255_ _255_/X _645_/Q _255_/B VPWR VGND sg13g2_and2_1
XFILLER_2_660 VPWR VGND sg13g2_decap_8
XFILLER_7_955 VPWR VGND sg13g2_decap_8
XFILLER_6_465 VPWR VGND sg13g2_fill_2
XFILLER_38_826 VPWR VGND sg13g2_decap_8
XFILLER_45_380 VPWR VGND sg13g2_decap_8
XFILLER_44_829 VPWR VGND sg13g2_decap_8
Xclkload1 clkload1/Y _456_/B VPWR VGND sg13g2_inv_2
XFILLER_20_781 VPWR VGND sg13g2_decap_8
XFILLER_4_925 VPWR VGND sg13g2_decap_8
XFILLER_43_840 VPWR VGND sg13g2_decap_8
XFILLER_43_851 VPWR VGND sg13g2_fill_1
XFILLER_47_667 VPWR VGND sg13g2_decap_8
X_307_ _310_/B _307_/A _307_/B VPWR VGND sg13g2_nand2_1
X_238_ _258_/A _253_/B VPWR VGND sg13g2_inv_1
XFILLER_7_752 VPWR VGND sg13g2_decap_8
XFILLER_3_980 VPWR VGND sg13g2_decap_8
XFILLER_14_1023 VPWR VGND sg13g2_decap_4
XFILLER_0_405 VPWR VGND sg13g2_fill_2
XFILLER_44_626 VPWR VGND sg13g2_decap_8
Xclkbuf_4_8_0_clk_regs clkbuf_4_8_0_clk_regs/X clkbuf_0_clk_regs/X VPWR VGND sg13g2_buf_8
XFILLER_3_298 VPWR VGND sg13g2_decap_8
XFILLER_4_799 VPWR VGND sg13g2_decap_8
XFILLER_4_722 VPWR VGND sg13g2_decap_8
XFILLER_48_987 VPWR VGND sg13g2_fill_1
XFILLER_47_464 VPWR VGND sg13g2_decap_8
XFILLER_31_821 VPWR VGND sg13g2_fill_2
XFILLER_7_582 VPWR VGND sg13g2_decap_8
XFILLER_22_810 VPWR VGND sg13g2_decap_8
XFILLER_0_224 VPWR VGND sg13g2_decap_8
XFILLER_0_235 VPWR VGND sg13g2_fill_1
XFILLER_1_758 VPWR VGND sg13g2_decap_8
Xoutput36 uo_out[6] _240_/X VPWR VGND sg13g2_buf_1
Xoutput25 uio_out[3] _245_/X VPWR VGND sg13g2_buf_1
Xoutput14 uio_oe[0] _249_/X VPWR VGND sg13g2_buf_1
X_572_ _572_/Q _574_/CLK _572_/D fanout96/X VPWR VGND sg13g2_dfrbpq_1
X_641_ _641_/Q _455_/Y _641_/D fanout72/X VPWR VGND sg13g2_dfrbpq_1
XFILLER_5_1010 VPWR VGND sg13g2_decap_8
XFILLER_13_854 VPWR VGND sg13g2_decap_8
XFILLER_44_467 VPWR VGND sg13g2_decap_8
XFILLER_9_847 VPWR VGND sg13g2_decap_8
XFILLER_4_596 VPWR VGND sg13g2_decap_8
XFILLER_48_740 VPWR VGND sg13g2_decap_8
XFILLER_39_784 VPWR VGND sg13g2_decap_8
XFILLER_10_802 VPWR VGND sg13g2_decap_8
XFILLER_10_879 VPWR VGND sg13g2_decap_8
XFILLER_5_349 VPWR VGND sg13g2_decap_8
XFILLER_1_555 VPWR VGND sg13g2_decap_8
Xclkbuf_5_26__f_clk_regs _567_/CLK clkbuf_4_13_0_clk_regs/X VPWR VGND sg13g2_buf_16
XFILLER_49_548 VPWR VGND sg13g2_decap_8
XFILLER_45_765 VPWR VGND sg13g2_decap_8
X_555_ _555_/Q _569_/CLK _555_/D fanout95/X VPWR VGND sg13g2_dfrbpq_1
X_624_ _624_/Q _624_/CLK _624_/D fanout68/X VPWR VGND sg13g2_dfrbpq_1
X_486_ _486_/Q _657_/CLK _486_/D fanout90/X VPWR VGND sg13g2_dfrbpq_1
XFILLER_17_990 VPWR VGND sg13g2_fill_2
XFILLER_36_798 VPWR VGND sg13g2_decap_8
XFILLER_12_49 VPWR VGND sg13g2_fill_2
Xhold110 _658_/D _462_/Q VPWR VGND sg13g2_dlygate4sd3_1
Xhold121 _614_/D _587_/Q VPWR VGND sg13g2_dlygate4sd3_1
XFILLER_2_1024 VPWR VGND sg13g2_decap_4
XFILLER_46_507 VPWR VGND sg13g2_decap_8
XFILLER_27_798 VPWR VGND sg13g2_decap_8
XFILLER_42_768 VPWR VGND sg13g2_decap_8
X_340_ _505_/D _504_/Q _505_/Q _413_/S VPWR VGND sg13g2_mux2_1
X_271_ _635_/D _613_/Q _627_/Q _278_/S VPWR VGND sg13g2_mux2_1
XFILLER_2_842 VPWR VGND sg13g2_decap_8
XFILLER_6_647 VPWR VGND sg13g2_decap_8
XFILLER_1_330 VPWR VGND sg13g2_decap_8
XFILLER_49_345 VPWR VGND sg13g2_decap_8
XFILLER_14_960 VPWR VGND sg13g2_decap_8
XFILLER_18_776 VPWR VGND sg13g2_decap_8
XFILLER_45_562 VPWR VGND sg13g2_decap_8
X_538_ _538_/Q _612_/CLK _538_/D fanout68/X VPWR VGND sg13g2_dfrbpq_1
X_607_ _607_/Q _622_/CLK _607_/D fanout72/X VPWR VGND sg13g2_dfrbpq_1
X_469_ _469_/Q _652_/CLK _469_/D fanout79/X VPWR VGND sg13g2_dfrbpq_1
Xclkbuf_4_10_0_clk_regs clkbuf_4_10_0_clk_regs/X clkbuf_0_clk_regs/X VPWR VGND sg13g2_buf_8
XFILLER_42_565 VPWR VGND sg13g2_decap_8
XFILLER_47_849 VPWR VGND sg13g2_fill_1
XFILLER_11_985 VPWR VGND sg13g2_decap_8
XFILLER_30_749 VPWR VGND sg13g2_decap_8
Xfanout60 fanout60/X _291_/Y VPWR VGND sg13g2_buf_1
Xfanout71 fanout71/X fanout74/X VPWR VGND sg13g2_buf_1
Xfanout93 fanout93/X fanout97/X VPWR VGND sg13g2_buf_1
Xfanout82 fanout82/X fanout83/X VPWR VGND sg13g2_buf_1
X_323_ _488_/D _487_/Q _488_/Q _323_/S VPWR VGND sg13g2_mux2_1
X_254_ _254_/X _643_/Q _255_/B VPWR VGND sg13g2_and2_1
XFILLER_7_934 VPWR VGND sg13g2_decap_8
XFILLER_38_805 VPWR VGND sg13g2_decap_8
XFILLER_21_749 VPWR VGND sg13g2_decap_8
Xdelaybuf_25_clk delaybuf_26_clk/A delaybuf_25_clk/A VPWR VGND sg13g2_buf_16
XFILLER_44_808 VPWR VGND sg13g2_decap_8
Xclkload2 clkload2/Y _449_/B VPWR VGND sg13g2_inv_4
XFILLER_1_4 VPWR VGND sg13g2_fill_1
XFILLER_3_436 VPWR VGND sg13g2_fill_2
Xdelaybuf_16_clk delaybuf_17_clk/A clkbuf_0_clk/X VPWR VGND sg13g2_buf_16
XFILLER_4_904 VPWR VGND sg13g2_decap_8
XFILLER_35_819 VPWR VGND sg13g2_decap_4
XFILLER_47_646 VPWR VGND sg13g2_decap_8
X_306_ _473_/D _473_/Q _307_/B VPWR VGND sg13g2_xor2_1
XFILLER_11_782 VPWR VGND sg13g2_decap_8
X_237_ _237_/X _281_/A _279_/B VPWR VGND sg13g2_and2_1
XFILLER_46_690 VPWR VGND sg13g2_decap_8
XFILLER_14_1002 VPWR VGND sg13g2_decap_8
XFILLER_17_819 VPWR VGND sg13g2_decap_8
XFILLER_44_605 VPWR VGND sg13g2_decap_8
XFILLER_40_833 VPWR VGND sg13g2_decap_8
XFILLER_4_701 VPWR VGND sg13g2_decap_8
XFILLER_0_984 VPWR VGND sg13g2_decap_8
XFILLER_3_255 VPWR VGND sg13g2_decap_8
XFILLER_4_778 VPWR VGND sg13g2_decap_8
XFILLER_47_443 VPWR VGND sg13g2_decap_8
XFILLER_43_693 VPWR VGND sg13g2_decap_8
XFILLER_7_561 VPWR VGND sg13g2_decap_8
XFILLER_25_0 VPWR VGND sg13g2_fill_2
XFILLER_41_619 VPWR VGND sg13g2_decap_8
Xclkbuf_5_25__f_clk_regs _514_/CLK clkbuf_4_12_0_clk_regs/X VPWR VGND sg13g2_buf_16
XFILLER_1_737 VPWR VGND sg13g2_decap_8
Xoutput37 uo_out[7] _241_/X VPWR VGND sg13g2_buf_1
Xoutput26 uio_out[4] _255_/B VPWR VGND sg13g2_buf_1
Xoutput15 uio_oe[1] _250_/X VPWR VGND sg13g2_buf_1
XFILLER_44_446 VPWR VGND sg13g2_decap_8
X_571_ _571_/Q _575_/CLK _571_/D fanout96/X VPWR VGND sg13g2_dfrbpq_1
X_640_ _640_/Q _454_/Y _640_/D fanout84/X VPWR VGND sg13g2_dfrbpq_1
XFILLER_13_833 VPWR VGND sg13g2_decap_8
XFILLER_9_826 VPWR VGND sg13g2_decap_8
XFILLER_4_575 VPWR VGND sg13g2_decap_8
XFILLER_0_781 VPWR VGND sg13g2_decap_8
Xclkbuf_0_clk_delayed clkbuf_0_clk_delayed/X clkbuf_0_clk_delayed/A VPWR VGND sg13g2_buf_16
XFILLER_48_796 VPWR VGND sg13g2_decap_8
XFILLER_47_284 VPWR VGND sg13g2_decap_8
XFILLER_11_1027 VPWR VGND sg13g2_fill_2
XFILLER_8_881 VPWR VGND sg13g2_decap_8
XFILLER_39_763 VPWR VGND sg13g2_decap_8
Xclkbuf_5_9__f_clk_regs _653_/CLK clkbuf_4_4_0_clk_regs/X VPWR VGND sg13g2_buf_16
XFILLER_10_858 VPWR VGND sg13g2_decap_8
XFILLER_5_328 VPWR VGND sg13g2_fill_1
XFILLER_1_534 VPWR VGND sg13g2_decap_8
XFILLER_49_527 VPWR VGND sg13g2_decap_8
XFILLER_44_254 VPWR VGND sg13g2_decap_8
XFILLER_44_298 VPWR VGND sg13g2_decap_4
XFILLER_45_744 VPWR VGND sg13g2_decap_8
X_554_ _554_/Q _567_/CLK _554_/D fanout95/X VPWR VGND sg13g2_dfrbpq_1
X_623_ _623_/Q _627_/CLK _623_/D fanout67/X VPWR VGND sg13g2_dfrbpq_1
X_485_ _485_/Q _485_/CLK _485_/D fanout90/X VPWR VGND sg13g2_dfrbpq_1
XFILLER_5_884 VPWR VGND sg13g2_decap_8
XFILLER_48_593 VPWR VGND sg13g2_decap_8
XFILLER_36_777 VPWR VGND sg13g2_decap_8
XFILLER_2_309 VPWR VGND sg13g2_decap_8
Xhold122 _619_/D _590_/Q VPWR VGND sg13g2_dlygate4sd3_1
Xhold111 _629_/D _600_/Q VPWR VGND sg13g2_dlygate4sd3_1
Xhold100 _259_/B _644_/Q VPWR VGND sg13g2_dlygate4sd3_1
XFILLER_27_777 VPWR VGND sg13g2_decap_8
XFILLER_2_1003 VPWR VGND sg13g2_decap_8
XFILLER_42_747 VPWR VGND sg13g2_decap_8
X_270_ _642_/D _608_/Q _622_/Q _277_/S VPWR VGND sg13g2_mux2_1
XFILLER_6_626 VPWR VGND sg13g2_decap_8
XFILLER_2_821 VPWR VGND sg13g2_decap_8
XFILLER_5_169 VPWR VGND sg13g2_decap_8
XFILLER_2_898 VPWR VGND sg13g2_decap_8
XFILLER_49_324 VPWR VGND sg13g2_decap_8
XFILLER_45_541 VPWR VGND sg13g2_decap_8
X_537_ _537_/Q _630_/CLK _537_/D fanout73/X VPWR VGND sg13g2_dfrbpq_1
X_606_ _606_/Q _621_/CLK _606_/D fanout84/X VPWR VGND sg13g2_dfrbpq_1
X_468_ _656_/D _444_/Y _468_/D fanout77/X VPWR VGND sg13g2_dfrbpq_1
XFILLER_41_780 VPWR VGND sg13g2_decap_8
X_399_ _564_/D _563_/Q _564_/Q _405_/S VPWR VGND sg13g2_mux2_1
Xclkbuf_leaf_4_clk _456_/B clkbuf_leaf_6_clk/A VPWR VGND sg13g2_buf_8
XFILLER_4_95 VPWR VGND sg13g2_fill_1
XFILLER_49_891 VPWR VGND sg13g2_decap_8
XFILLER_48_390 VPWR VGND sg13g2_decap_8
XFILLER_47_828 VPWR VGND sg13g2_decap_8
XFILLER_42_544 VPWR VGND sg13g2_decap_8
X_322_ _487_/D _486_/Q _487_/Q _323_/S VPWR VGND sg13g2_mux2_1
XFILLER_11_964 VPWR VGND sg13g2_decap_8
XFILLER_23_791 VPWR VGND sg13g2_decap_4
Xfanout50 _348_/S _350_/S VPWR VGND sg13g2_buf_1
Xfanout61 _249_/B _255_/B VPWR VGND sg13g2_buf_1
Xfanout72 fanout72/X fanout74/X VPWR VGND sg13g2_buf_1
Xfanout94 fanout94/X fanout95/X VPWR VGND sg13g2_buf_1
Xfanout83 fanout83/X fanout91/X VPWR VGND sg13g2_buf_1
X_253_ _253_/X _634_/Q _253_/B VPWR VGND sg13g2_and2_1
XFILLER_7_913 VPWR VGND sg13g2_decap_8
XFILLER_6_467 VPWR VGND sg13g2_fill_1
XFILLER_2_695 VPWR VGND sg13g2_decap_8
Xclkload20 clkload20/X _456_/A VPWR VGND sg13g2_buf_8
XFILLER_47_1026 VPWR VGND sg13g2_fill_2
XFILLER_29_817 VPWR VGND sg13g2_decap_8
Xclkload3 clkload3/Y _444_/B VPWR VGND sg13g2_inv_2
XFILLER_3_404 VPWR VGND sg13g2_fill_1
XFILLER_3_415 VPWR VGND sg13g2_decap_8
XFILLER_47_625 VPWR VGND sg13g2_decap_8
Xdelaybuf_9_clk delaybuf_9_clk/X delaybuf_9_clk/A VPWR VGND sg13g2_buf_16
X_305_ _472_/D _220_/Y _301_/Y _307_/B VPWR VGND sg13g2_a21oi_1
X_236_ _461_/D _236_/A0 _461_/Q _236_/S VPWR VGND sg13g2_mux2_1
XFILLER_7_787 VPWR VGND sg13g2_decap_8
XFILLER_7_710 VPWR VGND sg13g2_decap_4
XFILLER_26_809 VPWR VGND sg13g2_decap_8
Xclkbuf_5_24__f_clk_regs _575_/CLK clkbuf_4_12_0_clk_regs/X VPWR VGND sg13g2_buf_16
XFILLER_0_407 VPWR VGND sg13g2_fill_1
XFILLER_1_919 VPWR VGND sg13g2_decap_8
XFILLER_40_812 VPWR VGND sg13g2_decap_8
XFILLER_4_757 VPWR VGND sg13g2_decap_8
XFILLER_0_963 VPWR VGND sg13g2_decap_8
XFILLER_48_912 VPWR VGND sg13g2_fill_1
XFILLER_48_901 VPWR VGND sg13g2_decap_8
XFILLER_47_422 VPWR VGND sg13g2_decap_8
XFILLER_43_672 VPWR VGND sg13g2_decap_8
XFILLER_47_499 VPWR VGND sg13g2_decap_8
XFILLER_31_823 VPWR VGND sg13g2_fill_1
X_219_ _304_/A _470_/Q VPWR VGND sg13g2_inv_1
XFILLER_22_845 VPWR VGND sg13g2_decap_8
Xclkbuf_5_8__f_clk_regs _658_/CLK clkbuf_4_4_0_clk_regs/X VPWR VGND sg13g2_buf_16
XFILLER_0_204 VPWR VGND sg13g2_fill_1
XFILLER_1_716 VPWR VGND sg13g2_decap_8
Xoutput27 uio_out[5] _246_/X VPWR VGND sg13g2_buf_1
Xoutput16 uio_oe[2] _251_/X VPWR VGND sg13g2_buf_1
XFILLER_49_709 VPWR VGND sg13g2_decap_8
XFILLER_44_425 VPWR VGND sg13g2_decap_8
X_570_ _570_/Q _570_/CLK _570_/D fanout94/X VPWR VGND sg13g2_dfrbpq_1
XFILLER_13_812 VPWR VGND sg13g2_decap_8
XFILLER_13_889 VPWR VGND sg13g2_decap_8
XFILLER_9_805 VPWR VGND sg13g2_decap_8
XFILLER_4_554 VPWR VGND sg13g2_decap_8
XFILLER_0_760 VPWR VGND sg13g2_decap_8
XFILLER_48_775 VPWR VGND sg13g2_decap_8
XFILLER_47_263 VPWR VGND sg13g2_decap_8
Xclkbuf_0_clk clkbuf_0_clk/X clk VPWR VGND sg13g2_buf_16
XFILLER_11_1006 VPWR VGND sg13g2_decap_8
XFILLER_8_860 VPWR VGND sg13g2_decap_8
XFILLER_7_381 VPWR VGND sg13g2_fill_2
XFILLER_10_837 VPWR VGND sg13g2_decap_8
XFILLER_6_819 VPWR VGND sg13g2_decap_8
X_622_ _622_/Q _622_/CLK _622_/D fanout73/X VPWR VGND sg13g2_dfrbpq_1
XFILLER_49_506 VPWR VGND sg13g2_decap_8
XFILLER_45_723 VPWR VGND sg13g2_decap_8
X_553_ _553_/Q _568_/CLK _553_/D fanout95/X VPWR VGND sg13g2_dfrbpq_1
X_484_ _484_/Q _485_/CLK _484_/D fanout90/X VPWR VGND sg13g2_dfrbpq_1
XFILLER_5_863 VPWR VGND sg13g2_decap_8
XFILLER_36_756 VPWR VGND sg13g2_decap_8
XFILLER_48_572 VPWR VGND sg13g2_decap_8
Xhold123 _608_/D _581_/Q VPWR VGND sg13g2_dlygate4sd3_1
Xhold112 _605_/D _578_/Q VPWR VGND sg13g2_dlygate4sd3_1
Xhold101 _648_/D _259_/X VPWR VGND sg13g2_dlygate4sd3_1
XFILLER_27_756 VPWR VGND sg13g2_decap_8
XFILLER_42_726 VPWR VGND sg13g2_decap_8
XFILLER_6_605 VPWR VGND sg13g2_decap_8
XFILLER_5_137 VPWR VGND sg13g2_decap_4
XFILLER_5_126 VPWR VGND sg13g2_fill_1
XFILLER_1_365 VPWR VGND sg13g2_fill_2
XFILLER_2_800 VPWR VGND sg13g2_decap_8
XFILLER_2_877 VPWR VGND sg13g2_decap_8
Xclkbuf_2_3__f_clk_delayed _452_/A clkbuf_0_clk_delayed/X VPWR VGND sg13g2_buf_16
XFILLER_49_303 VPWR VGND sg13g2_decap_8
XFILLER_45_520 VPWR VGND sg13g2_decap_8
X_605_ _605_/Q _622_/CLK _605_/D fanout84/X VPWR VGND sg13g2_dfrbpq_1
XFILLER_14_995 VPWR VGND sg13g2_decap_8
XFILLER_45_597 VPWR VGND sg13g2_decap_8
X_536_ _536_/Q _608_/CLK _536_/D fanout71/X VPWR VGND sg13g2_dfrbpq_1
X_467_ _655_/D _443_/Y _467_/D fanout77/X VPWR VGND sg13g2_dfrbpq_1
X_398_ _563_/D _562_/Q _563_/Q _398_/S VPWR VGND sg13g2_mux2_1
XFILLER_49_870 VPWR VGND sg13g2_decap_8
XFILLER_32_770 VPWR VGND sg13g2_decap_8
XFILLER_2_118 VPWR VGND sg13g2_fill_2
XFILLER_46_328 VPWR VGND sg13g2_fill_1
XFILLER_46_339 VPWR VGND sg13g2_decap_8
XFILLER_47_807 VPWR VGND sg13g2_decap_8
XFILLER_11_943 VPWR VGND sg13g2_decap_8
Xfanout40 _435_/S _436_/S VPWR VGND sg13g2_buf_1
Xfanout51 _410_/S _350_/S VPWR VGND sg13g2_buf_1
Xfanout62 _253_/B _255_/B VPWR VGND sg13g2_buf_1
Xfanout73 fanout73/X fanout74/X VPWR VGND sg13g2_buf_1
X_321_ _486_/D _485_/Q _486_/Q _350_/S VPWR VGND sg13g2_mux2_1
X_252_ _252_/X _633_/Q _253_/B VPWR VGND sg13g2_and2_1
Xfanout95 fanout95/X fanout97/X VPWR VGND sg13g2_buf_1
Xfanout84 fanout84/X fanout85/X VPWR VGND sg13g2_buf_1
XFILLER_7_969 VPWR VGND sg13g2_decap_8
XFILLER_2_674 VPWR VGND sg13g2_decap_8
XFILLER_45_394 VPWR VGND sg13g2_decap_8
XFILLER_46_851 VPWR VGND sg13g2_fill_1
XFILLER_14_792 VPWR VGND sg13g2_decap_8
Xclkbuf_5_23__f_clk_regs _485_/CLK clkbuf_4_11_0_clk_regs/X VPWR VGND sg13g2_buf_16
Xclkload10 clkload10/Y _488_/CLK VPWR VGND sg13g2_inv_1
X_519_ _519_/Q _521_/CLK _519_/D fanout81/X VPWR VGND sg13g2_dfrbpq_1
Xclkload21 clkload21/Y _452_/A VPWR VGND sg13g2_inv_4
XFILLER_6_980 VPWR VGND sg13g2_decap_8
XFILLER_20_795 VPWR VGND sg13g2_decap_8
Xclkload4 clkload4/Y _630_/CLK VPWR VGND sg13g2_inv_1
XFILLER_4_939 VPWR VGND sg13g2_decap_8
XFILLER_3_438 VPWR VGND sg13g2_fill_1
XFILLER_3_449 VPWR VGND sg13g2_fill_2
XFILLER_8_1021 VPWR VGND sg13g2_decap_8
XFILLER_47_604 VPWR VGND sg13g2_decap_8
X_304_ _307_/B _304_/A _369_/S _304_/C VPWR VGND sg13g2_nor3_1
X_235_ _462_/D _235_/A0 _462_/Q _236_/S VPWR VGND sg13g2_mux2_1
XFILLER_6_210 VPWR VGND sg13g2_decap_8
XFILLER_7_766 VPWR VGND sg13g2_decap_8
XFILLER_6_232 VPWR VGND sg13g2_fill_2
XFILLER_6_221 VPWR VGND sg13g2_fill_1
XFILLER_2_482 VPWR VGND sg13g2_decap_8
XFILLER_3_994 VPWR VGND sg13g2_decap_8
Xclkbuf_5_7__f_clk_regs _541_/CLK clkbuf_4_3_0_clk_regs/X VPWR VGND sg13g2_buf_16
XFILLER_25_843 VPWR VGND sg13g2_decap_8
XFILLER_3_202 VPWR VGND sg13g2_fill_2
XFILLER_4_736 VPWR VGND sg13g2_decap_8
XFILLER_0_942 VPWR VGND sg13g2_decap_8
Xclkbuf_regs_0_clk clkbuf_regs_0_clk/X delaybuf_28_clk/X VPWR VGND sg13g2_buf_16
XFILLER_48_957 VPWR VGND sg13g2_fill_1
XFILLER_47_401 VPWR VGND sg13g2_decap_8
XFILLER_16_843 VPWR VGND sg13g2_decap_8
XFILLER_43_651 VPWR VGND sg13g2_decap_8
XFILLER_47_478 VPWR VGND sg13g2_decap_8
X_218_ _218_/Y _469_/Q VPWR VGND sg13g2_inv_1
XFILLER_3_791 VPWR VGND sg13g2_decap_8
XFILLER_7_596 VPWR VGND sg13g2_decap_8
XFILLER_22_824 VPWR VGND sg13g2_decap_8
Xoutput28 uio_out[6] _247_/X VPWR VGND sg13g2_buf_1
Xoutput17 uio_oe[3] _252_/X VPWR VGND sg13g2_buf_1
XFILLER_5_1024 VPWR VGND sg13g2_decap_4
XFILLER_44_404 VPWR VGND sg13g2_decap_8
XFILLER_13_868 VPWR VGND sg13g2_decap_8
XFILLER_4_533 VPWR VGND sg13g2_decap_8
XFILLER_11_8 VPWR VGND sg13g2_fill_1
XFILLER_48_754 VPWR VGND sg13g2_decap_8
XFILLER_47_242 VPWR VGND sg13g2_decap_8
XFILLER_39_798 VPWR VGND sg13g2_decap_8
Xclkbuf_4_7_0_clk_regs clkbuf_4_7_0_clk_regs/X clkbuf_0_clk_regs/X VPWR VGND sg13g2_buf_8
XFILLER_10_816 VPWR VGND sg13g2_decap_8
XFILLER_1_569 VPWR VGND sg13g2_decap_8
XFILLER_45_702 VPWR VGND sg13g2_decap_8
X_621_ _621_/Q _621_/CLK _621_/D fanout71/X VPWR VGND sg13g2_dfrbpq_1
XFILLER_45_779 VPWR VGND sg13g2_decap_8
X_552_ _552_/Q _569_/CLK _552_/D fanout94/X VPWR VGND sg13g2_dfrbpq_1
X_483_ _483_/Q _485_/CLK _483_/D fanout96/X VPWR VGND sg13g2_dfrbpq_1
XFILLER_5_842 VPWR VGND sg13g2_decap_8
XFILLER_4_352 VPWR VGND sg13g2_fill_2
XFILLER_4_341 VPWR VGND sg13g2_decap_8
XFILLER_48_551 VPWR VGND sg13g2_decap_8
Xhold124 _625_/D _596_/Q VPWR VGND sg13g2_dlygate4sd3_1
Xhold113 _627_/D _598_/Q VPWR VGND sg13g2_dlygate4sd3_1
Xhold102 hold102/X _646_/Q VPWR VGND sg13g2_dlygate4sd3_1
XFILLER_15_919 VPWR VGND sg13g2_decap_8
XFILLER_41_259 VPWR VGND sg13g2_decap_8
XFILLER_42_705 VPWR VGND sg13g2_decap_8
XFILLER_2_856 VPWR VGND sg13g2_decap_8
XFILLER_45_576 VPWR VGND sg13g2_decap_8
X_604_ _604_/Q _658_/CLK _604_/D fanout75/X VPWR VGND sg13g2_dfrbpq_1
X_535_ _535_/Q _535_/CLK _535_/D fanout82/X VPWR VGND sg13g2_dfrbpq_1
XFILLER_49_359 VPWR VGND sg13g2_decap_8
XFILLER_14_974 VPWR VGND sg13g2_decap_8
XFILLER_33_749 VPWR VGND sg13g2_decap_8
Xclkbuf_5_22__f_clk_regs _513_/CLK clkbuf_4_11_0_clk_regs/X VPWR VGND sg13g2_buf_16
X_466_ _466_/Q _442_/Y _466_/D fanout75/X VPWR VGND sg13g2_dfrbpq_1
X_397_ _562_/D _561_/Q _562_/Q _397_/S VPWR VGND sg13g2_mux2_1
XFILLER_5_683 VPWR VGND sg13g2_decap_8
XFILLER_24_749 VPWR VGND sg13g2_decap_8
XFILLER_3_609 VPWR VGND sg13g2_decap_8
Xdelaybuf_28_clk delaybuf_28_clk/X delaybuf_28_clk/A VPWR VGND sg13g2_buf_16
XFILLER_11_922 VPWR VGND sg13g2_decap_8
XFILLER_15_749 VPWR VGND sg13g2_fill_2
XFILLER_42_579 VPWR VGND sg13g2_decap_8
Xfanout41 _436_/S _419_/S VPWR VGND sg13g2_buf_1
Xfanout52 _323_/S _350_/S VPWR VGND sg13g2_buf_1
Xfanout63 _255_/B _237_/X VPWR VGND sg13g2_buf_1
Xfanout74 fanout74/X fanout91/X VPWR VGND sg13g2_buf_1
Xfanout96 fanout96/X fanout97/X VPWR VGND sg13g2_buf_1
Xfanout85 fanout85/X fanout88/X VPWR VGND sg13g2_buf_1
X_320_ _485_/D _484_/Q _485_/Q _350_/S VPWR VGND sg13g2_mux2_1
X_251_ _251_/X _632_/Q _253_/B VPWR VGND sg13g2_and2_1
XFILLER_11_999 VPWR VGND sg13g2_decap_8
Xdelaybuf_19_clk delaybuf_20_clk/A delaybuf_19_clk/A VPWR VGND sg13g2_buf_16
XFILLER_7_948 VPWR VGND sg13g2_decap_8
XFILLER_6_458 VPWR VGND sg13g2_decap_8
XFILLER_2_653 VPWR VGND sg13g2_decap_8
XFILLER_38_819 VPWR VGND sg13g2_decap_8
Xclkbuf_5_6__f_clk_regs _655_/CLK clkbuf_4_3_0_clk_regs/X VPWR VGND sg13g2_buf_16
XFILLER_45_373 VPWR VGND sg13g2_decap_8
X_518_ _518_/Q _535_/CLK _518_/D fanout81/X VPWR VGND sg13g2_dfrbpq_1
XFILLER_46_830 VPWR VGND sg13g2_decap_8
Xclkload11 clkload11/Y _620_/CLK VPWR VGND sg13g2_inv_1
X_449_ _449_/Y _452_/A _449_/B VPWR VGND sg13g2_xnor2_1
XFILLER_47_1028 VPWR VGND sg13g2_fill_1
Xclkload5 clkload5/Y _612_/CLK VPWR VGND sg13g2_inv_1
XFILLER_20_774 VPWR VGND sg13g2_decap_8
XFILLER_4_918 VPWR VGND sg13g2_decap_8
XFILLER_8_1000 VPWR VGND sg13g2_decap_8
XFILLER_43_833 VPWR VGND sg13g2_decap_8
XFILLER_11_796 VPWR VGND sg13g2_decap_8
X_303_ _304_/C _469_/Q _471_/Q _472_/Q VPWR VGND sg13g2_nand3_1
X_234_ _463_/D _234_/A0 _659_/D _236_/S VPWR VGND sg13g2_mux2_1
XFILLER_3_973 VPWR VGND sg13g2_decap_8
XFILLER_14_1016 VPWR VGND sg13g2_decap_8
XFILLER_14_1027 VPWR VGND sg13g2_fill_2
XFILLER_20_19 VPWR VGND sg13g2_fill_2
XFILLER_25_822 VPWR VGND sg13g2_decap_8
XFILLER_44_619 VPWR VGND sg13g2_decap_8
XFILLER_45_27 VPWR VGND sg13g2_fill_1
Xclkbuf_0__017__regs clkbuf_0__017__regs/X clkbuf_regs_1_clk/X VPWR VGND sg13g2_buf_16
XFILLER_40_847 VPWR VGND sg13g2_decap_4
XFILLER_0_921 VPWR VGND sg13g2_decap_8
XFILLER_4_715 VPWR VGND sg13g2_decap_8
XFILLER_0_998 VPWR VGND sg13g2_decap_8
XFILLER_47_457 VPWR VGND sg13g2_decap_8
XFILLER_43_630 VPWR VGND sg13g2_decap_8
XFILLER_7_575 VPWR VGND sg13g2_decap_8
XFILLER_2_291 VPWR VGND sg13g2_decap_8
XFILLER_3_770 VPWR VGND sg13g2_decap_8
XFILLER_22_803 VPWR VGND sg13g2_decap_8
Xoutput29 uio_out[7] _248_/X VPWR VGND sg13g2_buf_1
Xoutput18 uio_oe[4] _253_/X VPWR VGND sg13g2_buf_1
XFILLER_5_1003 VPWR VGND sg13g2_decap_8
XFILLER_13_847 VPWR VGND sg13g2_decap_8
XFILLER_4_512 VPWR VGND sg13g2_decap_8
XFILLER_4_589 VPWR VGND sg13g2_decap_8
XFILLER_0_795 VPWR VGND sg13g2_decap_8
XFILLER_48_733 VPWR VGND sg13g2_decap_8
XFILLER_47_298 VPWR VGND sg13g2_decap_8
XFILLER_46_70 VPWR VGND sg13g2_fill_2
XFILLER_43_460 VPWR VGND sg13g2_fill_1
XFILLER_43_471 VPWR VGND sg13g2_decap_8
XFILLER_8_895 VPWR VGND sg13g2_decap_8
XFILLER_7_383 VPWR VGND sg13g2_fill_1
XFILLER_39_777 VPWR VGND sg13g2_decap_8
XFILLER_1_548 VPWR VGND sg13g2_decap_8
XFILLER_45_758 VPWR VGND sg13g2_decap_8
X_551_ _551_/Q _567_/CLK _551_/D fanout93/X VPWR VGND sg13g2_dfrbpq_1
X_620_ _620_/Q _620_/CLK _620_/D fanout72/X VPWR VGND sg13g2_dfrbpq_1
XFILLER_44_268 VPWR VGND sg13g2_fill_2
Xclkbuf_5_21__f_clk_regs _506_/CLK clkbuf_4_10_0_clk_regs/X VPWR VGND sg13g2_buf_16
X_482_ _482_/Q _485_/CLK _482_/D fanout96/X VPWR VGND sg13g2_dfrbpq_1
XFILLER_5_898 VPWR VGND sg13g2_decap_8
XFILLER_5_821 VPWR VGND sg13g2_decap_8
XFILLER_0_592 VPWR VGND sg13g2_decap_8
XFILLER_48_530 VPWR VGND sg13g2_decap_8
XFILLER_44_780 VPWR VGND sg13g2_decap_8
Xhold125 _612_/D _585_/Q VPWR VGND sg13g2_dlygate4sd3_1
Xhold114 _606_/D _579_/Q VPWR VGND sg13g2_dlygate4sd3_1
Xhold103 _649_/D _657_/Q VPWR VGND sg13g2_dlygate4sd3_1
XFILLER_2_1017 VPWR VGND sg13g2_decap_8
XFILLER_2_1028 VPWR VGND sg13g2_fill_1
XFILLER_35_791 VPWR VGND sg13g2_decap_8
XFILLER_41_227 VPWR VGND sg13g2_fill_1
XFILLER_2_835 VPWR VGND sg13g2_decap_8
Xclkbuf_5_5__f_clk_regs _624_/CLK clkbuf_4_2_0_clk_regs/X VPWR VGND sg13g2_buf_16
XFILLER_49_338 VPWR VGND sg13g2_decap_8
XFILLER_18_769 VPWR VGND sg13g2_decap_8
XFILLER_45_555 VPWR VGND sg13g2_decap_8
X_603_ _603_/Q _658_/CLK _603_/D fanout75/X VPWR VGND sg13g2_dfrbpq_1
X_534_ _534_/Q _630_/CLK _534_/D fanout82/X VPWR VGND sg13g2_dfrbpq_1
X_465_ _465_/Q _441_/Y _465_/D fanout75/X VPWR VGND sg13g2_dfrbpq_1
XFILLER_14_953 VPWR VGND sg13g2_decap_8
XFILLER_41_794 VPWR VGND sg13g2_decap_8
X_396_ _561_/D _560_/Q _561_/Q _397_/S VPWR VGND sg13g2_mux2_1
XFILLER_5_662 VPWR VGND sg13g2_decap_8
XFILLER_17_791 VPWR VGND sg13g2_decap_8
XFILLER_11_901 VPWR VGND sg13g2_decap_8
XFILLER_11_978 VPWR VGND sg13g2_decap_8
XFILLER_42_558 VPWR VGND sg13g2_decap_8
Xfanout42 _431_/S _419_/S VPWR VGND sg13g2_buf_1
Xfanout53 _350_/S fanout54/X VPWR VGND sg13g2_buf_1
Xfanout64 fanout64/X fanout65/X VPWR VGND sg13g2_buf_1
Xfanout75 fanout75/X fanout76/X VPWR VGND sg13g2_buf_1
Xfanout97 fanout97/X input1/X VPWR VGND sg13g2_buf_1
Xfanout86 fanout86/X fanout88/X VPWR VGND sg13g2_buf_1
X_250_ _250_/X _631_/Q _253_/B VPWR VGND sg13g2_and2_1
XFILLER_7_927 VPWR VGND sg13g2_decap_8
XFILLER_2_632 VPWR VGND sg13g2_decap_8
XFILLER_38_71 VPWR VGND sg13g2_fill_2
XFILLER_45_352 VPWR VGND sg13g2_decap_8
X_517_ _517_/Q _660_/CLK _517_/D fanout80/X VPWR VGND sg13g2_dfrbpq_1
X_448_ _448_/Y _452_/A _459_/B VPWR VGND sg13g2_xnor2_1
XFILLER_41_591 VPWR VGND sg13g2_decap_8
Xclkload12 clkload12/Y _622_/CLK VPWR VGND sg13g2_inv_1
X_379_ _544_/D _543_/Q _544_/Q _391_/S VPWR VGND sg13g2_mux2_1
Xclkload6 clkload6/Y _624_/CLK VPWR VGND sg13g2_inv_1
XFILLER_3_429 VPWR VGND sg13g2_decap_8
XFILLER_47_639 VPWR VGND sg13g2_decap_8
XFILLER_43_812 VPWR VGND sg13g2_decap_8
X_302_ _471_/D _471_/Q _302_/B VPWR VGND sg13g2_xnor2_1
XFILLER_11_775 VPWR VGND sg13g2_decap_8
X_233_ _464_/D _233_/A0 _660_/D _236_/S VPWR VGND sg13g2_mux2_1
XFILLER_6_234 VPWR VGND sg13g2_fill_1
XFILLER_3_952 VPWR VGND sg13g2_decap_8
XFILLER_34_812 VPWR VGND sg13g2_fill_2
XFILLER_46_683 VPWR VGND sg13g2_decap_8
XFILLER_25_801 VPWR VGND sg13g2_decap_8
XFILLER_40_826 VPWR VGND sg13g2_decap_8
XFILLER_0_900 VPWR VGND sg13g2_decap_8
XFILLER_0_977 VPWR VGND sg13g2_decap_8
XFILLER_16_812 VPWR VGND sg13g2_decap_4
XFILLER_47_436 VPWR VGND sg13g2_decap_8
XFILLER_43_686 VPWR VGND sg13g2_decap_8
XFILLER_7_554 VPWR VGND sg13g2_decap_8
Xoutput19 uio_oe[5] _254_/X VPWR VGND sg13g2_buf_1
XFILLER_44_439 VPWR VGND sg13g2_decap_8
XFILLER_13_826 VPWR VGND sg13g2_decap_8
Xclkbuf_5_20__f_clk_regs _578_/CLK clkbuf_4_10_0_clk_regs/X VPWR VGND sg13g2_buf_16
XFILLER_9_819 VPWR VGND sg13g2_decap_8
XFILLER_4_568 VPWR VGND sg13g2_decap_8
XFILLER_0_774 VPWR VGND sg13g2_decap_8
XFILLER_48_712 VPWR VGND sg13g2_decap_8
XFILLER_48_789 VPWR VGND sg13g2_decap_8
XFILLER_47_277 VPWR VGND sg13g2_decap_8
XFILLER_8_874 VPWR VGND sg13g2_decap_8
XFILLER_7_87 VPWR VGND sg13g2_fill_2
XFILLER_16_0 VPWR VGND sg13g2_fill_1
XFILLER_39_756 VPWR VGND sg13g2_decap_8
XFILLER_1_527 VPWR VGND sg13g2_decap_8
Xclkbuf_5_4__f_clk_regs _627_/CLK clkbuf_4_2_0_clk_regs/X VPWR VGND sg13g2_buf_16
XFILLER_44_247 VPWR VGND sg13g2_decap_8
XFILLER_45_737 VPWR VGND sg13g2_decap_8
X_550_ _550_/Q _574_/CLK _550_/D fanout93/X VPWR VGND sg13g2_dfrbpq_1
X_481_ _481_/Q _485_/CLK _481_/D fanout89/X VPWR VGND sg13g2_dfrbpq_1
XFILLER_5_877 VPWR VGND sg13g2_decap_8
XFILLER_5_800 VPWR VGND sg13g2_decap_8
XFILLER_0_571 VPWR VGND sg13g2_decap_8
XFILLER_48_586 VPWR VGND sg13g2_decap_8
Xhold126 _615_/D _588_/Q VPWR VGND sg13g2_dlygate4sd3_1
Xhold115 _613_/D _586_/Q VPWR VGND sg13g2_dlygate4sd3_1
Xhold104 _651_/D _659_/Q VPWR VGND sg13g2_dlygate4sd3_1
XFILLER_35_770 VPWR VGND sg13g2_decap_8
XFILLER_2_814 VPWR VGND sg13g2_decap_8
XFILLER_6_619 VPWR VGND sg13g2_decap_8
X_602_ _602_/Q _653_/CLK _602_/D fanout80/X VPWR VGND sg13g2_dfrbpq_1
XFILLER_49_317 VPWR VGND sg13g2_decap_8
XFILLER_26_781 VPWR VGND sg13g2_decap_8
XFILLER_45_534 VPWR VGND sg13g2_decap_8
X_533_ _533_/Q _541_/CLK _533_/D fanout81/X VPWR VGND sg13g2_dfrbpq_1
X_464_ _660_/D _440_/Y _464_/D fanout78/X VPWR VGND sg13g2_dfrbpq_1
XFILLER_41_773 VPWR VGND sg13g2_decap_8
XFILLER_43_72 VPWR VGND sg13g2_fill_1
X_395_ _560_/D _559_/Q _560_/Q _398_/S VPWR VGND sg13g2_mux2_1
XFILLER_5_641 VPWR VGND sg13g2_decap_8
XFILLER_1_891 VPWR VGND sg13g2_decap_8
XFILLER_49_884 VPWR VGND sg13g2_decap_8
XFILLER_48_383 VPWR VGND sg13g2_decap_8
XFILLER_17_1026 VPWR VGND sg13g2_fill_2
XFILLER_17_770 VPWR VGND sg13g2_decap_8
XFILLER_32_784 VPWR VGND sg13g2_fill_2
XFILLER_9_980 VPWR VGND sg13g2_decap_8
XFILLER_11_957 VPWR VGND sg13g2_decap_8
XFILLER_23_795 VPWR VGND sg13g2_fill_1
Xfanout43 _419_/S _427_/S VPWR VGND sg13g2_buf_1
Xfanout54 fanout54/X fanout60/X VPWR VGND sg13g2_buf_1
Xfanout65 fanout65/X fanout67/X VPWR VGND sg13g2_buf_1
Xfanout76 fanout76/X fanout83/X VPWR VGND sg13g2_buf_1
Xfanout87 fanout87/X fanout88/X VPWR VGND sg13g2_buf_1
XFILLER_7_906 VPWR VGND sg13g2_decap_8
XFILLER_2_611 VPWR VGND sg13g2_decap_8
XFILLER_2_688 VPWR VGND sg13g2_decap_8
XFILLER_41_570 VPWR VGND sg13g2_decap_8
X_516_ _516_/Q _653_/CLK _516_/D fanout79/X VPWR VGND sg13g2_dfrbpq_1
X_447_ _447_/Y _452_/A _459_/B VPWR VGND sg13g2_xnor2_1
X_378_ _543_/D _542_/Q _543_/Q _391_/S VPWR VGND sg13g2_mux2_1
Xclkload13 clkload13/Y _506_/CLK VPWR VGND sg13g2_inv_1
XFILLER_6_994 VPWR VGND sg13g2_decap_8
XFILLER_47_1019 VPWR VGND sg13g2_decap_8
XFILLER_49_681 VPWR VGND sg13g2_decap_8
Xclkload7 clkload7/Y _541_/CLK VPWR VGND sg13g2_inv_1
XFILLER_47_618 VPWR VGND sg13g2_decap_8
XFILLER_24_41 VPWR VGND sg13g2_fill_1
X_301_ _301_/Y _469_/Q _470_/Q _471_/Q _311_/S VPWR VGND sg13g2_nand4_1
X_232_ _236_/S _647_/Q _648_/Q VPWR VGND sg13g2_nand2b_1
XFILLER_3_931 VPWR VGND sg13g2_decap_8
XFILLER_46_662 VPWR VGND sg13g2_decap_8
XFILLER_46_0 VPWR VGND sg13g2_fill_2
XFILLER_6_791 VPWR VGND sg13g2_decap_8
XFILLER_40_805 VPWR VGND sg13g2_decap_8
XFILLER_0_956 VPWR VGND sg13g2_decap_8
XFILLER_10_43 VPWR VGND sg13g2_fill_2
XFILLER_16_857 VPWR VGND sg13g2_decap_4
XFILLER_47_415 VPWR VGND sg13g2_decap_8
XFILLER_31_805 VPWR VGND sg13g2_decap_4
XFILLER_43_665 VPWR VGND sg13g2_decap_8
XFILLER_7_522 VPWR VGND sg13g2_decap_8
XFILLER_7_511 VPWR VGND sg13g2_fill_1
XFILLER_22_838 VPWR VGND sg13g2_decap_8
XFILLER_1_709 VPWR VGND sg13g2_decap_8
Xclkbuf_5_3__f_clk_regs _612_/CLK clkbuf_4_1_0_clk_regs/X VPWR VGND sg13g2_buf_16
XFILLER_44_418 VPWR VGND sg13g2_decap_8
XFILLER_13_805 VPWR VGND sg13g2_decap_8
XFILLER_4_547 VPWR VGND sg13g2_decap_8
XFILLER_0_753 VPWR VGND sg13g2_decap_8
XFILLER_48_768 VPWR VGND sg13g2_decap_8
XFILLER_47_256 VPWR VGND sg13g2_decap_8
XFILLER_12_893 VPWR VGND sg13g2_decap_8
XFILLER_8_853 VPWR VGND sg13g2_decap_8
XFILLER_7_99 VPWR VGND sg13g2_decap_4
XFILLER_45_716 VPWR VGND sg13g2_decap_8
X_480_ _480_/Q _657_/CLK _480_/D fanout89/X VPWR VGND sg13g2_dfrbpq_1
XFILLER_5_856 VPWR VGND sg13g2_decap_8
XFILLER_0_550 VPWR VGND sg13g2_decap_8
XFILLER_36_749 VPWR VGND sg13g2_decap_8
XFILLER_48_565 VPWR VGND sg13g2_decap_8
XFILLER_17_952 VPWR VGND sg13g2_fill_2
Xhold127 _621_/D _592_/Q VPWR VGND sg13g2_dlygate4sd3_1
Xhold116 _620_/D _591_/Q VPWR VGND sg13g2_dlygate4sd3_1
Xhold105 _652_/D _660_/Q VPWR VGND sg13g2_dlygate4sd3_1
XFILLER_27_749 VPWR VGND sg13g2_decap_8
XFILLER_42_719 VPWR VGND sg13g2_decap_8
XFILLER_45_513 VPWR VGND sg13g2_decap_8
X_601_ _601_/Q _609_/CLK _601_/D fanout66/X VPWR VGND sg13g2_dfrbpq_1
XFILLER_14_911 VPWR VGND sg13g2_decap_8
XFILLER_14_988 VPWR VGND sg13g2_decap_8
XFILLER_41_752 VPWR VGND sg13g2_decap_8
X_532_ _532_/Q _535_/CLK _532_/D fanout81/X VPWR VGND sg13g2_dfrbpq_1
X_463_ _659_/D _439_/Y _463_/D fanout78/X VPWR VGND sg13g2_dfrbpq_1
X_394_ _559_/D _558_/Q _559_/Q _397_/S VPWR VGND sg13g2_mux2_1
Xclkbuf_4_6_0_clk_regs clkbuf_4_6_0_clk_regs/X clkbuf_0_clk_regs/X VPWR VGND sg13g2_buf_8
XFILLER_5_620 VPWR VGND sg13g2_decap_8
XFILLER_1_870 VPWR VGND sg13g2_decap_8
XFILLER_5_697 VPWR VGND sg13g2_decap_8
XFILLER_49_863 VPWR VGND sg13g2_decap_8
XFILLER_48_362 VPWR VGND sg13g2_decap_8
XFILLER_32_763 VPWR VGND sg13g2_decap_8
XFILLER_23_763 VPWR VGND sg13g2_fill_2
XFILLER_42_516 VPWR VGND sg13g2_fill_1
Xfanout44 _429_/S _427_/S VPWR VGND sg13g2_buf_1
Xfanout55 _397_/S _398_/S VPWR VGND sg13g2_buf_1
XFILLER_11_936 VPWR VGND sg13g2_decap_8
Xfanout66 fanout66/X fanout67/X VPWR VGND sg13g2_buf_1
Xfanout77 fanout77/X fanout78/X VPWR VGND sg13g2_buf_1
Xfanout88 fanout88/X fanout91/X VPWR VGND sg13g2_buf_1
XFILLER_2_667 VPWR VGND sg13g2_decap_8
XFILLER_45_387 VPWR VGND sg13g2_decap_8
X_515_ _515_/Q _657_/CLK _515_/D fanout90/X VPWR VGND sg13g2_dfrbpq_1
XFILLER_46_844 VPWR VGND sg13g2_decap_8
X_446_ _446_/Y _452_/A _459_/B VPWR VGND sg13g2_xnor2_1
X_377_ _542_/D _541_/Q _542_/Q _398_/S VPWR VGND sg13g2_mux2_1
XFILLER_10_991 VPWR VGND sg13g2_decap_8
Xclkload14 clkload14/Y _485_/CLK VPWR VGND sg13g2_inv_1
XFILLER_6_973 VPWR VGND sg13g2_decap_8
XFILLER_5_483 VPWR VGND sg13g2_fill_2
XFILLER_49_660 VPWR VGND sg13g2_decap_8
XFILLER_20_788 VPWR VGND sg13g2_decap_8
Xclkload8 clkload8/Y _653_/CLK VPWR VGND sg13g2_inv_1
XFILLER_8_1014 VPWR VGND sg13g2_decap_8
XFILLER_42_302 VPWR VGND sg13g2_decap_4
XFILLER_43_847 VPWR VGND sg13g2_decap_4
X_300_ _470_/D _302_/B _300_/B VPWR VGND sg13g2_and2_1
X_231_ _465_/D _236_/A0 _465_/Q _231_/S VPWR VGND sg13g2_mux2_1
XFILLER_3_910 VPWR VGND sg13g2_decap_8
XFILLER_7_759 VPWR VGND sg13g2_decap_8
XFILLER_19_811 VPWR VGND sg13g2_decap_8
XFILLER_3_987 VPWR VGND sg13g2_decap_8
XFILLER_1_79 VPWR VGND sg13g2_fill_2
XFILLER_34_814 VPWR VGND sg13g2_fill_1
XFILLER_46_641 VPWR VGND sg13g2_decap_8
X_429_ _594_/D _593_/Q _623_/D _429_/S VPWR VGND sg13g2_mux2_1
Xclkbuf_5_2__f_clk_regs _609_/CLK clkbuf_4_1_0_clk_regs/X VPWR VGND sg13g2_buf_16
XFILLER_6_770 VPWR VGND sg13g2_decap_8
Xinput1 input1/X rst_n VPWR VGND sg13g2_buf_1
XFILLER_25_836 VPWR VGND sg13g2_decap_8
XFILLER_4_729 VPWR VGND sg13g2_decap_8
XFILLER_0_935 VPWR VGND sg13g2_decap_8
XFILLER_43_644 VPWR VGND sg13g2_decap_8
XFILLER_2_272 VPWR VGND sg13g2_fill_2
XFILLER_3_784 VPWR VGND sg13g2_decap_8
XFILLER_7_589 VPWR VGND sg13g2_decap_8
XFILLER_47_961 VPWR VGND sg13g2_fill_2
XFILLER_47_950 VPWR VGND sg13g2_fill_1
XFILLER_22_817 VPWR VGND sg13g2_decap_8
XFILLER_46_493 VPWR VGND sg13g2_decap_8
XFILLER_5_1028 VPWR VGND sg13g2_fill_1
XFILLER_5_1017 VPWR VGND sg13g2_decap_8
XFILLER_0_732 VPWR VGND sg13g2_decap_8
Xdelaybuf_2_clk delaybuf_3_clk/A delaybuf_2_clk/A VPWR VGND sg13g2_buf_16
XFILLER_4_526 VPWR VGND sg13g2_decap_8
XFILLER_48_747 VPWR VGND sg13g2_decap_8
XFILLER_47_235 VPWR VGND sg13g2_decap_8
XFILLER_43_485 VPWR VGND sg13g2_decap_4
XFILLER_12_872 VPWR VGND sg13g2_decap_8
XFILLER_8_832 VPWR VGND sg13g2_decap_8
XFILLER_7_364 VPWR VGND sg13g2_decap_8
XFILLER_7_342 VPWR VGND sg13g2_decap_4
XFILLER_3_581 VPWR VGND sg13g2_decap_8
XFILLER_10_809 VPWR VGND sg13g2_decap_8
XFILLER_16_43 VPWR VGND sg13g2_fill_2
XFILLER_38_791 VPWR VGND sg13g2_decap_8
XFILLER_5_835 VPWR VGND sg13g2_decap_8
XFILLER_17_931 VPWR VGND sg13g2_decap_4
XFILLER_48_544 VPWR VGND sg13g2_decap_8
XFILLER_44_794 VPWR VGND sg13g2_decap_8
Xhold128 _628_/D _599_/Q VPWR VGND sg13g2_dlygate4sd3_1
Xhold117 _616_/D _589_/Q VPWR VGND sg13g2_dlygate4sd3_1
Xhold106 _650_/D _658_/Q VPWR VGND sg13g2_dlygate4sd3_1
XFILLER_4_890 VPWR VGND sg13g2_decap_8
XFILLER_1_337 VPWR VGND sg13g2_fill_1
XFILLER_2_849 VPWR VGND sg13g2_decap_8
XFILLER_45_569 VPWR VGND sg13g2_decap_8
X_600_ _600_/Q _612_/CLK _600_/D fanout64/X VPWR VGND sg13g2_dfrbpq_1
X_531_ _531_/Q _652_/CLK _531_/D fanout79/X VPWR VGND sg13g2_dfrbpq_1
XFILLER_14_967 VPWR VGND sg13g2_decap_8
XFILLER_41_731 VPWR VGND sg13g2_decap_8
X_462_ _462_/Q _438_/Y _462_/D fanout75/X VPWR VGND sg13g2_dfrbpq_1
X_393_ _558_/D _557_/Q _558_/Q _397_/S VPWR VGND sg13g2_mux2_1
XFILLER_5_676 VPWR VGND sg13g2_decap_8
XFILLER_4_164 VPWR VGND sg13g2_fill_1
XFILLER_49_842 VPWR VGND sg13g2_decap_8
XFILLER_44_591 VPWR VGND sg13g2_decap_8
XFILLER_17_1028 VPWR VGND sg13g2_fill_1
XFILLER_32_786 VPWR VGND sg13g2_fill_1
XFILLER_11_915 VPWR VGND sg13g2_decap_8
Xfanout45 _427_/S fanout54/X VPWR VGND sg13g2_buf_1
Xfanout56 _398_/S fanout60/X VPWR VGND sg13g2_buf_1
Xfanout67 fanout67/X fanout70/X VPWR VGND sg13g2_buf_1
Xfanout78 fanout78/X fanout80/X VPWR VGND sg13g2_buf_1
Xfanout89 fanout89/X fanout91/X VPWR VGND sg13g2_buf_1
XFILLER_2_646 VPWR VGND sg13g2_decap_8
XFILLER_45_366 VPWR VGND sg13g2_decap_8
X_514_ _514_/Q _514_/CLK _514_/D fanout86/X VPWR VGND sg13g2_dfrbpq_1
XFILLER_46_823 VPWR VGND sg13g2_decap_8
XFILLER_10_970 VPWR VGND sg13g2_decap_8
Xclkload15 clkload15/Y _514_/CLK VPWR VGND sg13g2_inv_1
X_445_ _445_/Y _452_/A _449_/B VPWR VGND sg13g2_xnor2_1
X_376_ _541_/D _540_/Q _541_/Q _419_/S VPWR VGND sg13g2_mux2_1
Xclkbuf_5_1__f_clk_regs _630_/CLK clkbuf_4_0_0_clk_regs/X VPWR VGND sg13g2_buf_16
XFILLER_6_952 VPWR VGND sg13g2_decap_8
XFILLER_37_812 VPWR VGND sg13g2_decap_8
XFILLER_37_823 VPWR VGND sg13g2_fill_2
Xclkload9 clkload9/Y _652_/CLK VPWR VGND sg13g2_inv_1
XFILLER_28_812 VPWR VGND sg13g2_decap_8
XFILLER_28_823 VPWR VGND sg13g2_fill_2
XFILLER_43_826 VPWR VGND sg13g2_decap_8
XFILLER_11_789 VPWR VGND sg13g2_decap_8
Xclkbuf_1_1__f__017__regs _461_/CLK clkbuf_0__017__regs/X VPWR VGND sg13g2_buf_16
X_230_ _466_/D _235_/A0 _466_/Q _231_/S VPWR VGND sg13g2_mux2_1
XFILLER_3_966 VPWR VGND sg13g2_decap_8
X_428_ _593_/D _592_/Q _593_/Q _429_/S VPWR VGND sg13g2_mux2_1
XFILLER_46_697 VPWR VGND sg13g2_decap_8
XFILLER_14_1009 VPWR VGND sg13g2_decap_8
X_359_ _524_/D _523_/Q _524_/Q _435_/S VPWR VGND sg13g2_mux2_1
XFILLER_5_292 VPWR VGND sg13g2_fill_1
XFILLER_25_815 VPWR VGND sg13g2_decap_8
Xinput2 _291_/B ui_in[0] VPWR VGND sg13g2_buf_1
XFILLER_0_914 VPWR VGND sg13g2_decap_8
XFILLER_10_45 VPWR VGND sg13g2_fill_1
XFILLER_4_708 VPWR VGND sg13g2_decap_8
XFILLER_43_623 VPWR VGND sg13g2_decap_8
XFILLER_7_568 VPWR VGND sg13g2_decap_8
XFILLER_2_284 VPWR VGND sg13g2_decap_8
XFILLER_3_763 VPWR VGND sg13g2_decap_8
XFILLER_46_472 VPWR VGND sg13g2_decap_8
XFILLER_47_984 VPWR VGND sg13g2_fill_1
XFILLER_15_881 VPWR VGND sg13g2_decap_8
XFILLER_30_851 VPWR VGND sg13g2_fill_1
XFILLER_0_711 VPWR VGND sg13g2_decap_8
XFILLER_0_788 VPWR VGND sg13g2_decap_8
XFILLER_48_726 VPWR VGND sg13g2_decap_8
XFILLER_12_851 VPWR VGND sg13g2_decap_8
XFILLER_43_442 VPWR VGND sg13g2_decap_8
XFILLER_8_811 VPWR VGND sg13g2_decap_8
XFILLER_8_888 VPWR VGND sg13g2_decap_8
XFILLER_7_321 VPWR VGND sg13g2_decap_8
XFILLER_3_560 VPWR VGND sg13g2_decap_8
XFILLER_46_280 VPWR VGND sg13g2_decap_8
XFILLER_38_770 VPWR VGND sg13g2_decap_8
XFILLER_10_1012 VPWR VGND sg13g2_decap_8
XFILLER_5_814 VPWR VGND sg13g2_decap_8
XFILLER_0_585 VPWR VGND sg13g2_decap_8
XFILLER_48_523 VPWR VGND sg13g2_decap_8
XFILLER_17_954 VPWR VGND sg13g2_fill_1
XFILLER_17_965 VPWR VGND sg13g2_decap_4
XFILLER_29_770 VPWR VGND sg13g2_decap_8
XFILLER_43_250 VPWR VGND sg13g2_decap_8
XFILLER_44_773 VPWR VGND sg13g2_decap_8
Xhold129 _259_/A _643_/Q VPWR VGND sg13g2_dlygate4sd3_1
Xhold118 _622_/D _593_/Q VPWR VGND sg13g2_dlygate4sd3_1
Xhold107 _657_/D _461_/Q VPWR VGND sg13g2_dlygate4sd3_1
XFILLER_35_784 VPWR VGND sg13g2_decap_8
XFILLER_2_828 VPWR VGND sg13g2_decap_8
XFILLER_41_710 VPWR VGND sg13g2_decap_8
XFILLER_45_548 VPWR VGND sg13g2_decap_8
X_530_ _530_/Q _658_/CLK _530_/D fanout76/X VPWR VGND sg13g2_dfrbpq_1
X_461_ _461_/Q _461_/CLK _461_/D fanout79/X VPWR VGND sg13g2_dfrbpq_1
XFILLER_14_946 VPWR VGND sg13g2_decap_8
XFILLER_26_795 VPWR VGND sg13g2_decap_8
XFILLER_41_787 VPWR VGND sg13g2_decap_8
X_392_ _557_/D _556_/Q _557_/Q _407_/S VPWR VGND sg13g2_mux2_1
Xclkbuf_5_0__f_clk_regs _629_/CLK clkbuf_4_0_0_clk_regs/X VPWR VGND sg13g2_buf_16
XFILLER_5_655 VPWR VGND sg13g2_decap_8
XFILLER_0_393 VPWR VGND sg13g2_fill_2
XFILLER_49_898 VPWR VGND sg13g2_decap_8
XFILLER_49_821 VPWR VGND sg13g2_decap_8
XFILLER_48_320 VPWR VGND sg13g2_fill_2
XFILLER_17_784 VPWR VGND sg13g2_decap_8
XFILLER_1_1010 VPWR VGND sg13g2_decap_8
XFILLER_44_570 VPWR VGND sg13g2_decap_8
X_659_ _659_/Q _660_/CLK _659_/D fanout80/X VPWR VGND sg13g2_dfrbpq_1
XFILLER_48_397 VPWR VGND sg13g2_decap_8
XFILLER_9_994 VPWR VGND sg13g2_decap_8
XFILLER_13_45 VPWR VGND sg13g2_fill_1
XFILLER_23_765 VPWR VGND sg13g2_fill_1
Xfanout46 _370_/S fanout54/X VPWR VGND sg13g2_buf_1
Xfanout57 _405_/S _391_/S VPWR VGND sg13g2_buf_1
Xfanout68 fanout68/X fanout69/X VPWR VGND sg13g2_buf_1
Xfanout79 fanout79/X fanout80/X VPWR VGND sg13g2_buf_1
XFILLER_2_625 VPWR VGND sg13g2_decap_8
XFILLER_46_802 VPWR VGND sg13g2_decap_8
XFILLER_45_345 VPWR VGND sg13g2_decap_8
X_513_ _513_/Q _513_/CLK _513_/D fanout87/X VPWR VGND sg13g2_dfrbpq_1
X_444_ _444_/Y _459_/A _444_/B VPWR VGND sg13g2_xnor2_1
XFILLER_41_584 VPWR VGND sg13g2_decap_8
Xclkload16 clkload16/Y _568_/CLK VPWR VGND sg13g2_inv_1
X_375_ _540_/D _539_/Q _540_/Q _431_/S VPWR VGND sg13g2_mux2_1
XFILLER_6_931 VPWR VGND sg13g2_decap_8
XFILLER_5_496 VPWR VGND sg13g2_decap_8
XFILLER_5_485 VPWR VGND sg13g2_fill_1
XFILLER_49_695 VPWR VGND sg13g2_decap_8
XFILLER_9_791 VPWR VGND sg13g2_decap_8
XFILLER_43_805 VPWR VGND sg13g2_decap_8
XFILLER_2_444 VPWR VGND sg13g2_decap_4
XFILLER_3_945 VPWR VGND sg13g2_decap_8
XFILLER_34_805 VPWR VGND sg13g2_decap_8
XFILLER_46_676 VPWR VGND sg13g2_decap_8
X_427_ _592_/D _591_/Q _592_/Q _427_/S VPWR VGND sg13g2_mux2_1
X_358_ _523_/D _522_/Q _523_/Q _436_/S VPWR VGND sg13g2_mux2_1
X_289_ _289_/Y _226_/Y _258_/A _288_/Y VPWR VGND sg13g2_o21ai_1
Xdelaybuf_21_clk delaybuf_22_clk/A delaybuf_21_clk/A VPWR VGND sg13g2_buf_16
XFILLER_40_819 VPWR VGND sg13g2_decap_8
Xinput3 input3/X ui_in[1] VPWR VGND sg13g2_buf_1
XFILLER_49_492 VPWR VGND sg13g2_decap_8
XFILLER_16_805 VPWR VGND sg13g2_decap_8
XFILLER_16_816 VPWR VGND sg13g2_fill_2
XFILLER_43_602 VPWR VGND sg13g2_decap_8
Xdelaybuf_12_clk delaybuf_13_clk/A delaybuf_12_clk/A VPWR VGND sg13g2_buf_16
XFILLER_48_908 VPWR VGND sg13g2_decap_4
XFILLER_47_429 VPWR VGND sg13g2_decap_8
XFILLER_43_679 VPWR VGND sg13g2_decap_8
XFILLER_7_547 VPWR VGND sg13g2_decap_8
XFILLER_7_536 VPWR VGND sg13g2_fill_1
XFILLER_46_451 VPWR VGND sg13g2_decap_8
XFILLER_47_963 VPWR VGND sg13g2_fill_1
XFILLER_15_860 VPWR VGND sg13g2_decap_8
Xclkbuf_1_0__f__017_ _258_/B clkbuf_0__017_/X VPWR VGND sg13g2_buf_16
XFILLER_6_591 VPWR VGND sg13g2_decap_8
XFILLER_13_819 VPWR VGND sg13g2_decap_8
XFILLER_0_767 VPWR VGND sg13g2_decap_8
XFILLER_48_705 VPWR VGND sg13g2_decap_8
XFILLER_43_421 VPWR VGND sg13g2_decap_8
XFILLER_12_830 VPWR VGND sg13g2_decap_8
XFILLER_7_300 VPWR VGND sg13g2_decap_8
XFILLER_8_867 VPWR VGND sg13g2_decap_8
XFILLER_7_399 VPWR VGND sg13g2_decap_8
XFILLER_7_388 VPWR VGND sg13g2_decap_8
XFILLER_39_749 VPWR VGND sg13g2_decap_8
XFILLER_47_793 VPWR VGND sg13g2_decap_8
XFILLER_16_45 VPWR VGND sg13g2_fill_1
XFILLER_4_314 VPWR VGND sg13g2_decap_4
XFILLER_0_564 VPWR VGND sg13g2_decap_8
XFILLER_48_579 VPWR VGND sg13g2_decap_8
XFILLER_48_502 VPWR VGND sg13g2_decap_8
XFILLER_17_900 VPWR VGND sg13g2_decap_4
XFILLER_44_752 VPWR VGND sg13g2_decap_8
Xhold108 _630_/D _601_/Q VPWR VGND sg13g2_dlygate4sd3_1
XFILLER_7_141 VPWR VGND sg13g2_fill_1
XFILLER_7_130 VPWR VGND sg13g2_decap_8
Xhold119 _611_/D _584_/Q VPWR VGND sg13g2_dlygate4sd3_1
XFILLER_47_590 VPWR VGND sg13g2_decap_8
XFILLER_35_763 VPWR VGND sg13g2_decap_8
XFILLER_2_807 VPWR VGND sg13g2_decap_8
XFILLER_14_925 VPWR VGND sg13g2_decap_4
XFILLER_26_774 VPWR VGND sg13g2_decap_8
XFILLER_45_527 VPWR VGND sg13g2_decap_8
X_460_ _460_/Y _460_/A _460_/B VPWR VGND sg13g2_xnor2_1
X_391_ _556_/D _555_/Q _556_/Q _391_/S VPWR VGND sg13g2_mux2_1
XFILLER_41_766 VPWR VGND sg13g2_decap_8
XFILLER_5_634 VPWR VGND sg13g2_decap_8
XFILLER_4_122 VPWR VGND sg13g2_fill_2
XFILLER_49_800 VPWR VGND sg13g2_decap_8
XFILLER_0_372 VPWR VGND sg13g2_decap_8
XFILLER_1_884 VPWR VGND sg13g2_decap_8
XFILLER_49_877 VPWR VGND sg13g2_decap_8
XFILLER_48_376 VPWR VGND sg13g2_decap_8
XFILLER_13_980 VPWR VGND sg13g2_decap_8
XFILLER_17_1019 VPWR VGND sg13g2_decap_8
XFILLER_17_763 VPWR VGND sg13g2_decap_8
XFILLER_32_777 VPWR VGND sg13g2_decap_8
X_589_ _589_/Q _621_/CLK _589_/D fanout73/X VPWR VGND sg13g2_dfrbpq_1
X_658_ _658_/Q _658_/CLK _658_/D fanout75/X VPWR VGND sg13g2_dfrbpq_1
XFILLER_9_973 VPWR VGND sg13g2_decap_8
Xfanout47 _369_/S fanout54/X VPWR VGND sg13g2_buf_1
Xfanout58 _391_/S fanout60/X VPWR VGND sg13g2_buf_1
Xfanout69 fanout69/X fanout70/X VPWR VGND sg13g2_buf_1
XFILLER_2_604 VPWR VGND sg13g2_decap_8
XFILLER_14_799 VPWR VGND sg13g2_decap_8
XFILLER_41_563 VPWR VGND sg13g2_decap_8
X_512_ _512_/Q _575_/CLK _512_/D fanout86/X VPWR VGND sg13g2_dfrbpq_1
X_443_ _443_/Y _459_/A _460_/B VPWR VGND sg13g2_xnor2_1
X_374_ _539_/D _538_/Q _539_/Q _431_/S VPWR VGND sg13g2_mux2_1
Xclkload17 clkload17/Y _570_/CLK VPWR VGND sg13g2_inv_1
XFILLER_6_987 VPWR VGND sg13g2_decap_8
XFILLER_6_910 VPWR VGND sg13g2_decap_8
XFILLER_1_681 VPWR VGND sg13g2_decap_8
Xclkbuf_leaf_0_clk _459_/B clkbuf_leaf_6_clk/A VPWR VGND sg13g2_buf_8
XFILLER_49_674 VPWR VGND sg13g2_decap_8
XFILLER_44_390 VPWR VGND sg13g2_decap_8
XFILLER_9_770 VPWR VGND sg13g2_decap_8
Xclkbuf_4_5_0_clk_regs clkbuf_4_5_0_clk_regs/X clkbuf_0_clk_regs/X VPWR VGND sg13g2_buf_8
XFILLER_8_1028 VPWR VGND sg13g2_fill_1
XFILLER_40_66 VPWR VGND sg13g2_fill_1
XFILLER_6_217 VPWR VGND sg13g2_decap_4
XFILLER_2_489 VPWR VGND sg13g2_decap_8
XFILLER_3_924 VPWR VGND sg13g2_decap_8
XFILLER_46_655 VPWR VGND sg13g2_decap_8
XFILLER_41_371 VPWR VGND sg13g2_fill_2
X_426_ _591_/D _590_/Q _591_/Q _427_/S VPWR VGND sg13g2_mux2_1
X_357_ _522_/D _521_/Q _522_/Q _370_/S VPWR VGND sg13g2_mux2_1
X_288_ _288_/Y _288_/A1 _279_/Y _281_/Y _288_/B2 VPWR VGND sg13g2_a22oi_1
XFILLER_6_784 VPWR VGND sg13g2_decap_8
Xinput4 _281_/A ui_in[2] VPWR VGND sg13g2_buf_1
XFILLER_49_471 VPWR VGND sg13g2_decap_8
XFILLER_0_949 VPWR VGND sg13g2_decap_8
XFILLER_47_408 VPWR VGND sg13g2_decap_8
XFILLER_31_809 VPWR VGND sg13g2_fill_2
XFILLER_43_658 VPWR VGND sg13g2_decap_8
XFILLER_7_504 VPWR VGND sg13g2_decap_8
XFILLER_13_1022 VPWR VGND sg13g2_decap_8
Xdelaybuf_5_clk delaybuf_6_clk/A delaybuf_5_clk/A VPWR VGND sg13g2_buf_16
XFILLER_4_0 VPWR VGND sg13g2_fill_1
XFILLER_2_253 VPWR VGND sg13g2_decap_4
XFILLER_3_798 VPWR VGND sg13g2_decap_8
XFILLER_46_430 VPWR VGND sg13g2_decap_8
XFILLER_42_691 VPWR VGND sg13g2_decap_8
X_409_ _574_/D _573_/Q _574_/Q _410_/S VPWR VGND sg13g2_mux2_1
XFILLER_37_0 VPWR VGND sg13g2_fill_1
XFILLER_0_746 VPWR VGND sg13g2_decap_8
XFILLER_43_400 VPWR VGND sg13g2_fill_2
XFILLER_47_249 VPWR VGND sg13g2_decap_8
XFILLER_12_886 VPWR VGND sg13g2_decap_8
XFILLER_8_846 VPWR VGND sg13g2_decap_8
XFILLER_3_595 VPWR VGND sg13g2_decap_8
XFILLER_47_772 VPWR VGND sg13g2_decap_8
XFILLER_45_709 VPWR VGND sg13g2_decap_8
XFILLER_5_849 VPWR VGND sg13g2_decap_8
XFILLER_4_348 VPWR VGND sg13g2_decap_4
XFILLER_0_543 VPWR VGND sg13g2_decap_8
XFILLER_48_558 VPWR VGND sg13g2_decap_8
XFILLER_17_945 VPWR VGND sg13g2_decap_8
XFILLER_44_731 VPWR VGND sg13g2_decap_8
Xhold109 _654_/D _466_/Q VPWR VGND sg13g2_dlygate4sd3_1
XFILLER_7_197 VPWR VGND sg13g2_fill_2
XFILLER_7_186 VPWR VGND sg13g2_fill_1
XFILLER_3_392 VPWR VGND sg13g2_fill_2
XFILLER_45_506 VPWR VGND sg13g2_fill_2
XFILLER_14_904 VPWR VGND sg13g2_decap_8
XFILLER_41_745 VPWR VGND sg13g2_decap_8
X_390_ _555_/D _554_/Q _555_/Q _391_/S VPWR VGND sg13g2_mux2_1
XFILLER_5_613 VPWR VGND sg13g2_decap_8
XFILLER_0_351 VPWR VGND sg13g2_decap_8
XFILLER_1_863 VPWR VGND sg13g2_decap_8
X_657_ _657_/Q _657_/CLK _657_/D fanout82/X VPWR VGND sg13g2_dfrbpq_1
XFILLER_49_856 VPWR VGND sg13g2_decap_8
XFILLER_48_355 VPWR VGND sg13g2_decap_8
XFILLER_48_322 VPWR VGND sg13g2_fill_1
XFILLER_32_756 VPWR VGND sg13g2_decap_8
X_588_ _588_/Q _609_/CLK _588_/D fanout66/X VPWR VGND sg13g2_dfrbpq_1
XFILLER_9_952 VPWR VGND sg13g2_decap_8
XFILLER_23_756 VPWR VGND sg13g2_decap_8
XFILLER_11_929 VPWR VGND sg13g2_decap_8
Xfanout48 _413_/S _415_/S VPWR VGND sg13g2_buf_1
Xfanout59 _407_/S fanout60/X VPWR VGND sg13g2_buf_1
X_511_ _511_/Q _574_/CLK _511_/D fanout87/X VPWR VGND sg13g2_dfrbpq_1
XFILLER_46_837 VPWR VGND sg13g2_decap_8
X_442_ _442_/Y _459_/A _442_/B VPWR VGND sg13g2_xnor2_1
X_373_ _538_/D _537_/Q _538_/Q _431_/S VPWR VGND sg13g2_mux2_1
XFILLER_10_984 VPWR VGND sg13g2_decap_8
Xclkload18 clkload18/Y _461_/CLK VPWR VGND sg13g2_inv_1
XFILLER_6_966 VPWR VGND sg13g2_decap_8
XFILLER_5_476 VPWR VGND sg13g2_decap_8
XFILLER_5_443 VPWR VGND sg13g2_decap_4
XFILLER_0_170 VPWR VGND sg13g2_decap_8
XFILLER_1_660 VPWR VGND sg13g2_decap_8
XFILLER_49_653 VPWR VGND sg13g2_decap_8
XFILLER_8_1007 VPWR VGND sg13g2_decap_8
XFILLER_42_306 VPWR VGND sg13g2_fill_2
XFILLER_2_402 VPWR VGND sg13g2_decap_8
XFILLER_3_903 VPWR VGND sg13g2_decap_8
XFILLER_19_804 VPWR VGND sg13g2_decap_8
XFILLER_46_634 VPWR VGND sg13g2_decap_8
XFILLER_10_781 VPWR VGND sg13g2_decap_8
X_425_ _590_/D _589_/Q _590_/Q _429_/S VPWR VGND sg13g2_mux2_1
X_356_ _521_/D _520_/Q _521_/Q _370_/S VPWR VGND sg13g2_mux2_1
X_287_ _287_/Y _225_/Y _258_/A _286_/Y VPWR VGND sg13g2_o21ai_1
XFILLER_6_763 VPWR VGND sg13g2_decap_8
Xinput5 _279_/B ui_in[3] VPWR VGND sg13g2_buf_1
XFILLER_49_450 VPWR VGND sg13g2_decap_8
XFILLER_25_829 VPWR VGND sg13g2_decap_8
XFILLER_33_851 VPWR VGND sg13g2_fill_1
XFILLER_0_928 VPWR VGND sg13g2_decap_8
XFILLER_24_840 VPWR VGND sg13g2_decap_8
XFILLER_43_637 VPWR VGND sg13g2_decap_8
XFILLER_13_1001 VPWR VGND sg13g2_decap_8
XFILLER_24_851 VPWR VGND sg13g2_fill_1
XFILLER_2_243 VPWR VGND sg13g2_fill_1
XFILLER_3_700 VPWR VGND sg13g2_decap_8
XFILLER_3_777 VPWR VGND sg13g2_decap_8
XFILLER_2_298 VPWR VGND sg13g2_fill_1
XFILLER_15_895 VPWR VGND sg13g2_decap_8
XFILLER_42_670 VPWR VGND sg13g2_decap_8
XFILLER_46_486 VPWR VGND sg13g2_decap_8
X_408_ _573_/D _572_/Q _573_/Q _410_/S VPWR VGND sg13g2_mux2_1
X_339_ _504_/D _503_/Q _504_/Q _413_/S VPWR VGND sg13g2_mux2_1
X_257__98 _648_/CLK _257__99/A VPWR VGND sg13g2_inv_1
XFILLER_4_519 VPWR VGND sg13g2_decap_8
XFILLER_0_725 VPWR VGND sg13g2_decap_8
XFILLER_47_228 VPWR VGND sg13g2_decap_8
XFILLER_43_456 VPWR VGND sg13g2_decap_4
XFILLER_43_478 VPWR VGND sg13g2_decap_8
XFILLER_43_489 VPWR VGND sg13g2_fill_1
XFILLER_12_865 VPWR VGND sg13g2_decap_8
XFILLER_8_825 VPWR VGND sg13g2_decap_8
XFILLER_7_357 VPWR VGND sg13g2_decap_8
XFILLER_7_346 VPWR VGND sg13g2_fill_1
XFILLER_7_335 VPWR VGND sg13g2_decap_8
XFILLER_3_574 VPWR VGND sg13g2_decap_8
XFILLER_46_294 VPWR VGND sg13g2_decap_8
XFILLER_47_751 VPWR VGND sg13g2_decap_8
XFILLER_38_784 VPWR VGND sg13g2_decap_8
XFILLER_5_828 VPWR VGND sg13g2_decap_8
XFILLER_0_522 VPWR VGND sg13g2_decap_8
XFILLER_10_1026 VPWR VGND sg13g2_fill_2
XFILLER_0_599 VPWR VGND sg13g2_decap_8
XFILLER_29_784 VPWR VGND sg13g2_fill_2
XFILLER_44_710 VPWR VGND sg13g2_decap_8
XFILLER_48_537 VPWR VGND sg13g2_decap_8
XFILLER_43_264 VPWR VGND sg13g2_decap_4
XFILLER_43_286 VPWR VGND sg13g2_fill_2
XFILLER_44_787 VPWR VGND sg13g2_decap_8
XFILLER_3_371 VPWR VGND sg13g2_decap_8
XFILLER_4_883 VPWR VGND sg13g2_decap_8
XFILLER_35_798 VPWR VGND sg13g2_decap_8
XFILLER_8_70 VPWR VGND sg13g2_fill_2
XFILLER_27_35 VPWR VGND sg13g2_fill_1
XFILLER_41_724 VPWR VGND sg13g2_decap_8
XFILLER_5_669 VPWR VGND sg13g2_decap_8
XFILLER_1_842 VPWR VGND sg13g2_decap_8
XFILLER_49_835 VPWR VGND sg13g2_decap_8
XFILLER_17_798 VPWR VGND sg13g2_decap_8
XFILLER_1_1024 VPWR VGND sg13g2_decap_4
XFILLER_44_584 VPWR VGND sg13g2_decap_8
X_587_ _587_/Q _629_/CLK _587_/D fanout64/X VPWR VGND sg13g2_dfrbpq_1
X_656_ _656_/Q _660_/CLK _656_/D fanout77/X VPWR VGND sg13g2_dfrbpq_1
XFILLER_9_931 VPWR VGND sg13g2_decap_8
XFILLER_4_680 VPWR VGND sg13g2_decap_8
XFILLER_11_908 VPWR VGND sg13g2_decap_8
Xfanout38 _278_/S _277_/S VPWR VGND sg13g2_buf_1
Xfanout49 _415_/S _350_/S VPWR VGND sg13g2_buf_1
XFILLER_2_639 VPWR VGND sg13g2_decap_8
Xclkbuf_5_31__f_clk_regs _569_/CLK clkbuf_4_15_0_clk_regs/X VPWR VGND sg13g2_buf_16
XFILLER_45_359 VPWR VGND sg13g2_decap_8
X_510_ _510_/Q _578_/CLK _510_/D fanout84/X VPWR VGND sg13g2_dfrbpq_1
X_441_ _441_/Y _459_/A _442_/B VPWR VGND sg13g2_xnor2_1
XFILLER_46_816 VPWR VGND sg13g2_decap_8
XFILLER_10_963 VPWR VGND sg13g2_decap_8
XFILLER_41_598 VPWR VGND sg13g2_decap_8
X_372_ _537_/D _536_/Q _537_/Q _429_/S VPWR VGND sg13g2_mux2_1
Xclkload19 clkload19/Y _459_/A VPWR VGND sg13g2_inv_2
XFILLER_6_945 VPWR VGND sg13g2_decap_8
XFILLER_37_805 VPWR VGND sg13g2_decap_8
XFILLER_49_632 VPWR VGND sg13g2_decap_8
X_639_ _639_/Q _453_/Y _639_/D fanout84/X VPWR VGND sg13g2_dfrbpq_1
Xdelaybuf_24_clk delaybuf_25_clk/A delaybuf_24_clk/A VPWR VGND sg13g2_buf_16
XFILLER_28_805 VPWR VGND sg13g2_decap_8
XFILLER_43_819 VPWR VGND sg13g2_decap_8
XFILLER_3_959 VPWR VGND sg13g2_decap_8
Xdelaybuf_15_clk delaybuf_15_clk/X _456_/B VPWR VGND sg13g2_buf_16
XFILLER_49_66 VPWR VGND sg13g2_fill_2
XFILLER_41_340 VPWR VGND sg13g2_fill_2
X_424_ _589_/D _588_/Q _589_/Q _436_/S VPWR VGND sg13g2_mux2_1
X_355_ _520_/D _519_/Q _520_/Q _370_/S VPWR VGND sg13g2_mux2_1
X_286_ _286_/Y _286_/A1 _279_/Y _281_/Y _286_/B2 VPWR VGND sg13g2_a22oi_1
XFILLER_6_720 VPWR VGND sg13g2_fill_1
XFILLER_25_808 VPWR VGND sg13g2_decap_8
Xinput6 _603_/D ui_in[4] VPWR VGND sg13g2_buf_1
XFILLER_33_830 VPWR VGND sg13g2_decap_8
XFILLER_0_907 VPWR VGND sg13g2_decap_8
XFILLER_43_616 VPWR VGND sg13g2_decap_8
XFILLER_2_200 VPWR VGND sg13g2_fill_2
XFILLER_3_756 VPWR VGND sg13g2_decap_8
Xclkbuf_2_2__f_clk_delayed _456_/A clkbuf_0_clk_delayed/X VPWR VGND sg13g2_buf_16
XFILLER_46_465 VPWR VGND sg13g2_decap_8
XFILLER_15_874 VPWR VGND sg13g2_decap_8
XFILLER_30_844 VPWR VGND sg13g2_decap_8
X_407_ _572_/D _571_/Q _572_/Q _407_/S VPWR VGND sg13g2_mux2_1
X_338_ _503_/D _502_/Q _503_/Q _413_/S VPWR VGND sg13g2_mux2_1
X_269_ _641_/D _607_/Q _621_/Q _277_/S VPWR VGND sg13g2_mux2_1
XFILLER_0_704 VPWR VGND sg13g2_decap_8
X_257__99 _647_/CLK _257__99/A VPWR VGND sg13g2_inv_1
XFILLER_48_719 VPWR VGND sg13g2_decap_8
XFILLER_12_844 VPWR VGND sg13g2_decap_8
XFILLER_43_402 VPWR VGND sg13g2_fill_1
XFILLER_43_435 VPWR VGND sg13g2_decap_8
XFILLER_8_804 VPWR VGND sg13g2_decap_8
XFILLER_7_314 VPWR VGND sg13g2_decap_8
XFILLER_3_553 VPWR VGND sg13g2_decap_8
XFILLER_46_273 VPWR VGND sg13g2_decap_8
XFILLER_47_730 VPWR VGND sg13g2_decap_8
XFILLER_7_892 VPWR VGND sg13g2_decap_8
XFILLER_38_763 VPWR VGND sg13g2_decap_8
XFILLER_10_1005 VPWR VGND sg13g2_decap_8
XFILLER_5_807 VPWR VGND sg13g2_decap_8
XFILLER_0_501 VPWR VGND sg13g2_decap_8
XFILLER_0_578 VPWR VGND sg13g2_decap_8
XFILLER_48_516 VPWR VGND sg13g2_decap_8
XFILLER_17_969 VPWR VGND sg13g2_fill_1
XFILLER_29_763 VPWR VGND sg13g2_decap_8
XFILLER_29_796 VPWR VGND sg13g2_decap_8
XFILLER_44_766 VPWR VGND sg13g2_decap_8
XFILLER_3_350 VPWR VGND sg13g2_decap_8
XFILLER_4_862 VPWR VGND sg13g2_decap_8
XFILLER_35_777 VPWR VGND sg13g2_decap_8
Xclkbuf_5_30__f_clk_regs _560_/CLK clkbuf_4_15_0_clk_regs/X VPWR VGND sg13g2_buf_16
XFILLER_45_508 VPWR VGND sg13g2_fill_1
XFILLER_14_939 VPWR VGND sg13g2_decap_8
XFILLER_26_788 VPWR VGND sg13g2_decap_8
XFILLER_41_703 VPWR VGND sg13g2_decap_8
XFILLER_5_648 VPWR VGND sg13g2_decap_8
XFILLER_0_386 VPWR VGND sg13g2_decap_8
XFILLER_1_821 VPWR VGND sg13g2_decap_8
XFILLER_1_898 VPWR VGND sg13g2_decap_8
XFILLER_49_814 VPWR VGND sg13g2_decap_8
XFILLER_48_313 VPWR VGND sg13g2_decap_8
XFILLER_17_777 VPWR VGND sg13g2_decap_8
XFILLER_1_1003 VPWR VGND sg13g2_decap_8
XFILLER_44_563 VPWR VGND sg13g2_decap_8
X_586_ _586_/Q _629_/CLK _586_/D fanout64/X VPWR VGND sg13g2_dfrbpq_1
X_655_ _655_/Q _655_/CLK _655_/D fanout76/X VPWR VGND sg13g2_dfrbpq_1
XFILLER_13_994 VPWR VGND sg13g2_decap_8
XFILLER_40_791 VPWR VGND sg13g2_decap_8
XFILLER_9_987 VPWR VGND sg13g2_decap_8
XFILLER_9_910 VPWR VGND sg13g2_decap_8
Xclkbuf_leaf_3_clk _444_/B delaybuf_14_clk/X VPWR VGND sg13g2_buf_8
XFILLER_48_880 VPWR VGND sg13g2_decap_8
XFILLER_13_16 VPWR VGND sg13g2_fill_2
Xfanout39 _277_/S hold102/X VPWR VGND sg13g2_buf_1
XFILLER_2_618 VPWR VGND sg13g2_decap_8
XFILLER_31_791 VPWR VGND sg13g2_decap_8
XFILLER_45_338 VPWR VGND sg13g2_decap_8
X_440_ _440_/Y _460_/A _444_/B VPWR VGND sg13g2_xnor2_1
X_371_ _536_/D _535_/Q _536_/Q _429_/S VPWR VGND sg13g2_mux2_1
XFILLER_10_942 VPWR VGND sg13g2_decap_8
XFILLER_16_1022 VPWR VGND sg13g2_decap_8
XFILLER_41_577 VPWR VGND sg13g2_decap_8
XFILLER_6_924 VPWR VGND sg13g2_decap_8
XFILLER_1_695 VPWR VGND sg13g2_decap_8
XFILLER_49_688 VPWR VGND sg13g2_decap_8
XFILLER_49_611 VPWR VGND sg13g2_decap_8
X_569_ _569_/Q _569_/CLK _569_/D fanout94/X VPWR VGND sg13g2_dfrbpq_1
X_638_ _638_/Q _452_/Y _638_/D fanout73/X VPWR VGND sg13g2_dfrbpq_1
XFILLER_13_791 VPWR VGND sg13g2_decap_8
XFILLER_9_784 VPWR VGND sg13g2_decap_8
XFILLER_5_61 VPWR VGND sg13g2_fill_1
XFILLER_2_437 VPWR VGND sg13g2_decap_8
XFILLER_2_448 VPWR VGND sg13g2_fill_1
XFILLER_3_938 VPWR VGND sg13g2_decap_8
XFILLER_42_831 VPWR VGND sg13g2_decap_8
X_423_ _588_/D _587_/Q _588_/Q _436_/S VPWR VGND sg13g2_mux2_1
X_354_ _519_/D _518_/Q _519_/Q _370_/S VPWR VGND sg13g2_mux2_1
XFILLER_46_669 VPWR VGND sg13g2_decap_8
Xdelaybuf_8_clk delaybuf_9_clk/A clkload0/A VPWR VGND sg13g2_buf_16
X_285_ _285_/Y _224_/Y _258_/A _284_/Y VPWR VGND sg13g2_o21ai_1
XFILLER_2_982 VPWR VGND sg13g2_decap_8
XFILLER_6_798 VPWR VGND sg13g2_decap_8
Xinput7 _604_/D ui_in[5] VPWR VGND sg13g2_buf_1
XFILLER_49_485 VPWR VGND sg13g2_decap_8
XFILLER_7_529 VPWR VGND sg13g2_decap_8
XFILLER_46_444 VPWR VGND sg13g2_decap_8
XFILLER_47_912 VPWR VGND sg13g2_fill_1
XFILLER_15_853 VPWR VGND sg13g2_decap_8
Xclkbuf_4_4_0_clk_regs clkbuf_4_4_0_clk_regs/X clkbuf_0_clk_regs/X VPWR VGND sg13g2_buf_8
X_406_ _571_/D _570_/Q _571_/Q _407_/S VPWR VGND sg13g2_mux2_1
X_337_ _502_/D _501_/Q _502_/Q _413_/S VPWR VGND sg13g2_mux2_1
X_268_ _640_/D _606_/Q _620_/Q _277_/S VPWR VGND sg13g2_mux2_1
XFILLER_6_584 VPWR VGND sg13g2_decap_8
XFILLER_49_282 VPWR VGND sg13g2_decap_8
XFILLER_21_812 VPWR VGND sg13g2_decap_8
XFILLER_21_823 VPWR VGND sg13g2_fill_2
XFILLER_43_414 VPWR VGND sg13g2_decap_8
XFILLER_12_823 VPWR VGND sg13g2_decap_8
XFILLER_4_1023 VPWR VGND sg13g2_decap_4
XFILLER_46_230 VPWR VGND sg13g2_decap_8
XFILLER_47_786 VPWR VGND sg13g2_decap_8
Xinput10 _236_/A0 uio_in[0] VPWR VGND sg13g2_buf_1
XFILLER_7_871 VPWR VGND sg13g2_decap_8
XFILLER_10_1028 VPWR VGND sg13g2_fill_1
XFILLER_4_307 VPWR VGND sg13g2_decap_8
XFILLER_0_557 VPWR VGND sg13g2_decap_8
XFILLER_44_745 VPWR VGND sg13g2_decap_8
XFILLER_4_841 VPWR VGND sg13g2_decap_8
XFILLER_47_583 VPWR VGND sg13g2_decap_8
XFILLER_35_756 VPWR VGND sg13g2_decap_8
XFILLER_8_72 VPWR VGND sg13g2_fill_1
XFILLER_14_918 VPWR VGND sg13g2_decap_8
XFILLER_41_759 VPWR VGND sg13g2_decap_8
XFILLER_1_800 VPWR VGND sg13g2_decap_8
XFILLER_5_627 VPWR VGND sg13g2_decap_8
XFILLER_4_115 VPWR VGND sg13g2_decap_8
XFILLER_49_1024 VPWR VGND sg13g2_decap_4
XFILLER_1_877 VPWR VGND sg13g2_decap_8
X_654_ _654_/Q _658_/CLK _654_/D fanout76/X VPWR VGND sg13g2_dfrbpq_1
XFILLER_48_369 VPWR VGND sg13g2_decap_8
XFILLER_17_756 VPWR VGND sg13g2_decap_8
XFILLER_44_542 VPWR VGND sg13g2_decap_8
X_585_ _585_/Q _624_/CLK _585_/D fanout68/X VPWR VGND sg13g2_dfrbpq_1
XFILLER_13_973 VPWR VGND sg13g2_decap_8
XFILLER_40_770 VPWR VGND sg13g2_decap_8
XFILLER_9_966 VPWR VGND sg13g2_decap_8
XFILLER_47_380 VPWR VGND sg13g2_decap_8
XFILLER_31_770 VPWR VGND sg13g2_decap_8
XFILLER_45_306 VPWR VGND sg13g2_decap_8
XFILLER_41_556 VPWR VGND sg13g2_decap_8
X_370_ _535_/D _534_/Q _535_/Q _370_/S VPWR VGND sg13g2_mux2_1
XFILLER_10_921 VPWR VGND sg13g2_decap_8
XFILLER_10_998 VPWR VGND sg13g2_decap_8
XFILLER_22_770 VPWR VGND sg13g2_decap_8
XFILLER_22_781 VPWR VGND sg13g2_fill_1
XFILLER_6_903 VPWR VGND sg13g2_decap_8
XFILLER_1_674 VPWR VGND sg13g2_decap_8
XFILLER_0_184 VPWR VGND sg13g2_decap_4
XFILLER_45_851 VPWR VGND sg13g2_fill_1
X_637_ _637_/Q _451_/Y _637_/D fanout67/X VPWR VGND sg13g2_dfrbpq_1
XFILLER_49_667 VPWR VGND sg13g2_decap_8
XFILLER_44_383 VPWR VGND sg13g2_decap_8
X_568_ _568_/Q _568_/CLK _568_/D fanout94/X VPWR VGND sg13g2_dfrbpq_1
X_499_ _499_/Q _513_/CLK _499_/D fanout87/X VPWR VGND sg13g2_dfrbpq_1
XFILLER_9_763 VPWR VGND sg13g2_decap_8
XFILLER_24_27 VPWR VGND sg13g2_fill_1
XFILLER_3_917 VPWR VGND sg13g2_decap_8
XFILLER_19_818 VPWR VGND sg13g2_decap_8
XFILLER_27_840 VPWR VGND sg13g2_decap_8
XFILLER_27_851 VPWR VGND sg13g2_fill_1
XFILLER_46_648 VPWR VGND sg13g2_decap_8
XFILLER_42_810 VPWR VGND sg13g2_decap_8
X_422_ _587_/D _586_/Q _587_/Q _435_/S VPWR VGND sg13g2_mux2_1
X_353_ _518_/D _517_/Q _518_/Q _370_/S VPWR VGND sg13g2_mux2_1
X_284_ _284_/Y _284_/A1 _279_/Y _281_/Y _284_/B2 VPWR VGND sg13g2_a22oi_1
XFILLER_10_795 VPWR VGND sg13g2_decap_8
XFILLER_6_777 VPWR VGND sg13g2_decap_8
XFILLER_5_276 VPWR VGND sg13g2_fill_2
XFILLER_2_961 VPWR VGND sg13g2_decap_8
Xinput8 _617_/D ui_in[6] VPWR VGND sg13g2_buf_1
XFILLER_49_464 VPWR VGND sg13g2_decap_8
XFILLER_45_681 VPWR VGND sg13g2_decap_8
XFILLER_13_1015 VPWR VGND sg13g2_decap_8
XFILLER_2_202 VPWR VGND sg13g2_fill_1
XFILLER_3_714 VPWR VGND sg13g2_decap_8
XFILLER_2_257 VPWR VGND sg13g2_fill_1
XFILLER_2_268 VPWR VGND sg13g2_decap_4
XFILLER_15_832 VPWR VGND sg13g2_decap_8
XFILLER_46_423 VPWR VGND sg13g2_decap_8
XFILLER_42_684 VPWR VGND sg13g2_decap_8
X_405_ _570_/D _569_/Q _570_/Q _405_/S VPWR VGND sg13g2_mux2_1
X_336_ _501_/D _500_/Q _501_/Q _348_/S VPWR VGND sg13g2_mux2_1
X_267_ _639_/D _605_/Q _619_/Q _278_/S VPWR VGND sg13g2_mux2_1
XFILLER_49_261 VPWR VGND sg13g2_decap_8
XFILLER_0_739 VPWR VGND sg13g2_decap_8
XFILLER_12_802 VPWR VGND sg13g2_decap_8
XFILLER_12_879 VPWR VGND sg13g2_decap_8
XFILLER_8_839 VPWR VGND sg13g2_decap_8
XFILLER_3_588 VPWR VGND sg13g2_decap_8
XFILLER_4_1002 VPWR VGND sg13g2_decap_8
XFILLER_47_765 VPWR VGND sg13g2_decap_8
XFILLER_42_470 VPWR VGND sg13g2_decap_8
Xinput11 _235_/A0 uio_in[1] VPWR VGND sg13g2_buf_1
X_319_ _484_/D _483_/Q _484_/Q _323_/S VPWR VGND sg13g2_mux2_1
XFILLER_7_850 VPWR VGND sg13g2_decap_8
Xclkbuf_1_0__f_clk clkbuf_leaf_6_clk/A delaybuf_22_clk/X VPWR VGND sg13g2_buf_16
XFILLER_38_798 VPWR VGND sg13g2_decap_8
XFILLER_0_536 VPWR VGND sg13g2_decap_8
XFILLER_44_724 VPWR VGND sg13g2_decap_8
XFILLER_7_179 VPWR VGND sg13g2_decap_8
XFILLER_4_820 VPWR VGND sg13g2_decap_8
XFILLER_3_385 VPWR VGND sg13g2_decap_8
XFILLER_4_897 VPWR VGND sg13g2_decap_8
XFILLER_47_562 VPWR VGND sg13g2_decap_8
XFILLER_16_960 VPWR VGND sg13g2_decap_8
XFILLER_7_680 VPWR VGND sg13g2_decap_4
XFILLER_41_738 VPWR VGND sg13g2_decap_8
XFILLER_5_606 VPWR VGND sg13g2_decap_8
XFILLER_1_856 VPWR VGND sg13g2_decap_8
X_653_ _653_/Q _653_/CLK _653_/D fanout83/X VPWR VGND sg13g2_dfrbpq_1
XFILLER_49_849 VPWR VGND sg13g2_decap_8
XFILLER_48_348 VPWR VGND sg13g2_decap_8
XFILLER_13_952 VPWR VGND sg13g2_decap_8
XFILLER_32_749 VPWR VGND sg13g2_decap_8
XFILLER_44_598 VPWR VGND sg13g2_decap_8
X_584_ _584_/Q _655_/CLK _584_/D fanout69/X VPWR VGND sg13g2_dfrbpq_1
XFILLER_9_945 VPWR VGND sg13g2_decap_8
XFILLER_4_694 VPWR VGND sg13g2_decap_8
XFILLER_23_749 VPWR VGND sg13g2_decap_8
Xdelaybuf_27_clk delaybuf_28_clk/A delaybuf_27_clk/A VPWR VGND sg13g2_buf_16
XFILLER_10_900 VPWR VGND sg13g2_decap_8
XFILLER_14_749 VPWR VGND sg13g2_fill_2
XFILLER_41_502 VPWR VGND sg13g2_fill_2
XFILLER_10_977 VPWR VGND sg13g2_decap_8
Xdelaybuf_18_clk delaybuf_19_clk/A delaybuf_18_clk/A VPWR VGND sg13g2_buf_16
XFILLER_6_959 VPWR VGND sg13g2_decap_8
XFILLER_5_447 VPWR VGND sg13g2_fill_2
XFILLER_5_436 VPWR VGND sg13g2_decap_8
XFILLER_5_403 VPWR VGND sg13g2_decap_4
XFILLER_1_653 VPWR VGND sg13g2_decap_8
XFILLER_49_646 VPWR VGND sg13g2_decap_8
XFILLER_37_819 VPWR VGND sg13g2_decap_4
X_567_ _567_/Q _567_/CLK _567_/D fanout94/X VPWR VGND sg13g2_dfrbpq_1
X_636_ _636_/Q _450_/Y _636_/D fanout66/X VPWR VGND sg13g2_dfrbpq_1
X_498_ _498_/Q _513_/CLK _498_/D fanout87/X VPWR VGND sg13g2_dfrbpq_1
XFILLER_10_0 VPWR VGND sg13g2_fill_1
XFILLER_28_819 VPWR VGND sg13g2_decap_4
XFILLER_36_830 VPWR VGND sg13g2_fill_1
XFILLER_36_841 VPWR VGND sg13g2_decap_8
XFILLER_40_27 VPWR VGND sg13g2_fill_2
X_421_ _586_/D _585_/Q _586_/Q _435_/S VPWR VGND sg13g2_mux2_1
XFILLER_46_627 VPWR VGND sg13g2_decap_8
X_352_ _517_/D _516_/Q _517_/Q _369_/S VPWR VGND sg13g2_mux2_1
X_283_ _283_/Y _223_/Y _258_/A _282_/Y VPWR VGND sg13g2_o21ai_1
XFILLER_10_774 VPWR VGND sg13g2_decap_8
XFILLER_2_940 VPWR VGND sg13g2_decap_8
XFILLER_6_756 VPWR VGND sg13g2_decap_8
XFILLER_5_288 VPWR VGND sg13g2_decap_4
Xinput9 _618_/D ui_in[7] VPWR VGND sg13g2_buf_1
XFILLER_49_443 VPWR VGND sg13g2_decap_8
XFILLER_33_800 VPWR VGND sg13g2_fill_2
XFILLER_33_844 VPWR VGND sg13g2_decap_8
XFILLER_45_660 VPWR VGND sg13g2_decap_8
X_619_ _619_/Q _620_/CLK _619_/D fanout72/X VPWR VGND sg13g2_dfrbpq_1
XFILLER_24_800 VPWR VGND sg13g2_fill_1
XFILLER_24_833 VPWR VGND sg13g2_decap_8
XFILLER_4_5 VPWR VGND sg13g2_fill_1
XFILLER_46_402 VPWR VGND sg13g2_decap_8
XFILLER_15_811 VPWR VGND sg13g2_decap_8
XFILLER_15_888 VPWR VGND sg13g2_decap_8
XFILLER_30_814 VPWR VGND sg13g2_fill_2
XFILLER_42_663 VPWR VGND sg13g2_decap_8
XFILLER_46_479 VPWR VGND sg13g2_decap_8
X_404_ _569_/D _568_/Q _569_/Q _405_/S VPWR VGND sg13g2_mux2_1
XFILLER_41_173 VPWR VGND sg13g2_fill_2
XFILLER_41_70 VPWR VGND sg13g2_fill_2
X_335_ _500_/D _499_/Q _500_/Q _348_/S VPWR VGND sg13g2_mux2_1
X_266_ _643_/D _266_/A _266_/B VPWR VGND sg13g2_nand2_1
XFILLER_2_86 VPWR VGND sg13g2_fill_1
XFILLER_49_240 VPWR VGND sg13g2_decap_8
XFILLER_0_718 VPWR VGND sg13g2_decap_8
XFILLER_43_449 VPWR VGND sg13g2_decap_8
XFILLER_12_858 VPWR VGND sg13g2_decap_8
XFILLER_8_818 VPWR VGND sg13g2_decap_8
XFILLER_7_328 VPWR VGND sg13g2_fill_1
XFILLER_3_501 VPWR VGND sg13g2_fill_1
XFILLER_3_567 VPWR VGND sg13g2_decap_8
XFILLER_47_744 VPWR VGND sg13g2_decap_8
XFILLER_46_287 VPWR VGND sg13g2_decap_8
XFILLER_11_880 VPWR VGND sg13g2_decap_8
Xinput12 _234_/A0 uio_in[2] VPWR VGND sg13g2_buf_1
X_318_ _483_/D _482_/Q _483_/Q _407_/S VPWR VGND sg13g2_mux2_1
X_249_ _249_/X _642_/Q _249_/B VPWR VGND sg13g2_and2_1
XFILLER_38_777 VPWR VGND sg13g2_decap_8
XFILLER_0_515 VPWR VGND sg13g2_decap_8
XFILLER_10_1019 VPWR VGND sg13g2_decap_8
XFILLER_29_777 VPWR VGND sg13g2_decap_8
XFILLER_44_703 VPWR VGND sg13g2_decap_8
XFILLER_43_257 VPWR VGND sg13g2_decap_8
XFILLER_4_876 VPWR VGND sg13g2_decap_8
XFILLER_47_541 VPWR VGND sg13g2_decap_8
XFILLER_43_791 VPWR VGND sg13g2_decap_8
Xclkbuf_leaf_6_clk _449_/B clkbuf_leaf_6_clk/A VPWR VGND sg13g2_buf_8
XFILLER_34_791 VPWR VGND sg13g2_decap_8
XFILLER_41_717 VPWR VGND sg13g2_decap_8
XFILLER_1_835 VPWR VGND sg13g2_decap_8
XFILLER_49_828 VPWR VGND sg13g2_decap_8
XFILLER_1_1017 VPWR VGND sg13g2_decap_8
XFILLER_1_1028 VPWR VGND sg13g2_fill_1
X_583_ _610_/D _629_/CLK _583_/D fanout65/X VPWR VGND sg13g2_dfrbpq_1
X_652_ _652_/Q _652_/CLK _652_/D fanout78/X VPWR VGND sg13g2_dfrbpq_1
XFILLER_13_931 VPWR VGND sg13g2_decap_8
XFILLER_25_780 VPWR VGND sg13g2_decap_8
XFILLER_44_577 VPWR VGND sg13g2_decap_8
XFILLER_9_924 VPWR VGND sg13g2_decap_8
XFILLER_4_673 VPWR VGND sg13g2_decap_8
XFILLER_16_791 VPWR VGND sg13g2_decap_8
XFILLER_48_894 VPWR VGND sg13g2_decap_8
XFILLER_46_809 VPWR VGND sg13g2_decap_8
Xclkbuf_0__017_ clkbuf_0__017_/X _256_/Y VPWR VGND sg13g2_buf_16
XFILLER_10_956 VPWR VGND sg13g2_decap_8
XFILLER_6_938 VPWR VGND sg13g2_decap_8
XFILLER_1_632 VPWR VGND sg13g2_decap_8
XFILLER_49_625 VPWR VGND sg13g2_decap_8
XFILLER_45_842 VPWR VGND sg13g2_decap_8
X_566_ _566_/Q _568_/CLK _566_/D fanout94/X VPWR VGND sg13g2_dfrbpq_1
X_635_ _635_/Q _449_/Y _635_/D fanout64/X VPWR VGND sg13g2_dfrbpq_1
X_497_ _497_/Q _513_/CLK _497_/D fanout87/X VPWR VGND sg13g2_dfrbpq_1
XFILLER_9_798 VPWR VGND sg13g2_decap_8
XFILLER_5_982 VPWR VGND sg13g2_decap_8
XFILLER_5_42 VPWR VGND sg13g2_fill_2
XFILLER_5_31 VPWR VGND sg13g2_fill_2
XFILLER_48_691 VPWR VGND sg13g2_decap_8
XFILLER_6_9 VPWR VGND sg13g2_fill_1
XFILLER_42_845 VPWR VGND sg13g2_decap_8
X_420_ _585_/D _584_/Q _585_/Q _431_/S VPWR VGND sg13g2_mux2_1
X_351_ _516_/D _515_/Q _516_/Q _369_/S VPWR VGND sg13g2_mux2_1
X_282_ _282_/Y _282_/A1 _279_/Y _281_/Y _282_/B2 VPWR VGND sg13g2_a22oi_1
XFILLER_7_1001 VPWR VGND sg13g2_fill_1
XFILLER_2_996 VPWR VGND sg13g2_decap_8
XFILLER_49_499 VPWR VGND sg13g2_decap_8
XFILLER_49_422 VPWR VGND sg13g2_decap_8
X_549_ _549_/Q _570_/CLK _549_/D fanout92/X VPWR VGND sg13g2_dfrbpq_1
X_618_ _618_/Q _653_/CLK _618_/D fanout77/X VPWR VGND sg13g2_dfrbpq_1
XFILLER_24_812 VPWR VGND sg13g2_decap_8
XFILLER_43_609 VPWR VGND sg13g2_decap_8
XFILLER_3_749 VPWR VGND sg13g2_decap_8
XFILLER_46_458 VPWR VGND sg13g2_decap_8
XFILLER_15_867 VPWR VGND sg13g2_decap_8
XFILLER_30_837 VPWR VGND sg13g2_decap_8
XFILLER_42_642 VPWR VGND sg13g2_decap_8
X_403_ _568_/D _567_/Q _568_/Q _405_/S VPWR VGND sg13g2_mux2_1
X_334_ _499_/D _498_/Q _499_/Q _348_/S VPWR VGND sg13g2_mux2_1
X_265_ _644_/D _604_/Q _266_/A _264_/X VPWR VGND sg13g2_o21ai_1
XFILLER_2_43 VPWR VGND sg13g2_fill_2
XFILLER_2_793 VPWR VGND sg13g2_decap_8
XFILLER_6_598 VPWR VGND sg13g2_decap_8
XFILLER_2_65 VPWR VGND sg13g2_fill_2
XFILLER_49_296 VPWR VGND sg13g2_decap_8
XFILLER_12_837 VPWR VGND sg13g2_decap_8
XFILLER_43_428 VPWR VGND sg13g2_decap_8
XFILLER_7_307 VPWR VGND sg13g2_decap_8
XFILLER_3_546 VPWR VGND sg13g2_decap_8
XFILLER_46_222 VPWR VGND sg13g2_fill_2
XFILLER_46_244 VPWR VGND sg13g2_decap_4
XFILLER_46_266 VPWR VGND sg13g2_decap_8
XFILLER_47_723 VPWR VGND sg13g2_decap_8
Xinput13 _233_/A0 uio_in[3] VPWR VGND sg13g2_buf_1
X_317_ _482_/D _481_/Q _482_/Q _407_/S VPWR VGND sg13g2_mux2_1
X_248_ _248_/X _641_/Q _249_/B VPWR VGND sg13g2_and2_1
XFILLER_7_885 VPWR VGND sg13g2_decap_8
XFILLER_2_590 VPWR VGND sg13g2_decap_8
XFILLER_38_756 VPWR VGND sg13g2_decap_8
XFILLER_48_509 VPWR VGND sg13g2_decap_8
XFILLER_29_756 VPWR VGND sg13g2_decap_8
Xclkbuf_4_3_0_clk_regs clkbuf_4_3_0_clk_regs/X clkbuf_0_clk_regs/X VPWR VGND sg13g2_buf_8
XFILLER_44_759 VPWR VGND sg13g2_decap_8
XFILLER_7_137 VPWR VGND sg13g2_decap_4
XFILLER_4_855 VPWR VGND sg13g2_decap_8
XFILLER_47_520 VPWR VGND sg13g2_decap_8
XFILLER_43_770 VPWR VGND sg13g2_decap_8
XFILLER_47_597 VPWR VGND sg13g2_decap_8
XFILLER_8_64 VPWR VGND sg13g2_fill_1
XFILLER_34_770 VPWR VGND sg13g2_decap_8
XFILLER_0_379 VPWR VGND sg13g2_decap_8
XFILLER_1_814 VPWR VGND sg13g2_decap_8
XFILLER_49_807 VPWR VGND sg13g2_decap_8
XFILLER_48_306 VPWR VGND sg13g2_decap_8
XFILLER_13_910 VPWR VGND sg13g2_decap_8
XFILLER_44_556 VPWR VGND sg13g2_decap_8
X_582_ _609_/D _630_/CLK _582_/D fanout66/X VPWR VGND sg13g2_dfrbpq_1
X_651_ _651_/Q _652_/CLK _651_/D fanout78/X VPWR VGND sg13g2_dfrbpq_1
XFILLER_13_987 VPWR VGND sg13g2_decap_8
XFILLER_40_784 VPWR VGND sg13g2_decap_8
XFILLER_9_903 VPWR VGND sg13g2_decap_8
XFILLER_3_162 VPWR VGND sg13g2_decap_4
XFILLER_4_652 VPWR VGND sg13g2_decap_8
XFILLER_48_873 VPWR VGND sg13g2_decap_8
XFILLER_47_394 VPWR VGND sg13g2_decap_8
XFILLER_31_784 VPWR VGND sg13g2_decap_8
XFILLER_7_490 VPWR VGND sg13g2_decap_8
XFILLER_39_840 VPWR VGND sg13g2_decap_8
XFILLER_39_851 VPWR VGND sg13g2_fill_1
XFILLER_10_935 VPWR VGND sg13g2_decap_8
XFILLER_6_917 VPWR VGND sg13g2_decap_8
XFILLER_0_121 VPWR VGND sg13g2_fill_2
XFILLER_1_611 VPWR VGND sg13g2_decap_8
XFILLER_1_688 VPWR VGND sg13g2_decap_8
XFILLER_28_50 VPWR VGND sg13g2_fill_1
XFILLER_28_61 VPWR VGND sg13g2_fill_2
XFILLER_28_72 VPWR VGND sg13g2_fill_1
XFILLER_45_821 VPWR VGND sg13g2_decap_8
X_634_ _634_/Q _448_/Y _634_/D fanout76/X VPWR VGND sg13g2_dfrbpq_1
XFILLER_49_604 VPWR VGND sg13g2_decap_8
XFILLER_44_397 VPWR VGND sg13g2_decap_8
X_565_ _565_/Q _567_/CLK _565_/D fanout94/X VPWR VGND sg13g2_dfrbpq_1
X_496_ _496_/Q _514_/CLK _496_/D fanout86/X VPWR VGND sg13g2_dfrbpq_1
XFILLER_9_777 VPWR VGND sg13g2_decap_8
XFILLER_5_961 VPWR VGND sg13g2_decap_8
XFILLER_48_670 VPWR VGND sg13g2_decap_8
XFILLER_41_367 VPWR VGND sg13g2_decap_4
XFILLER_42_824 VPWR VGND sg13g2_decap_8
X_350_ _515_/D _514_/Q _515_/Q _350_/S VPWR VGND sg13g2_mux2_1
X_281_ _281_/Y _281_/A _279_/B VPWR VGND sg13g2_nor2b_1
XFILLER_2_975 VPWR VGND sg13g2_decap_8
XFILLER_49_401 VPWR VGND sg13g2_decap_8
XFILLER_33_813 VPWR VGND sg13g2_decap_8
X_617_ _617_/Q _653_/CLK _617_/D fanout75/X VPWR VGND sg13g2_dfrbpq_1
XFILLER_49_478 VPWR VGND sg13g2_decap_8
XFILLER_45_695 VPWR VGND sg13g2_decap_8
X_548_ _548_/Q _570_/CLK _548_/D fanout92/X VPWR VGND sg13g2_dfrbpq_1
X_479_ _479_/Q _488_/CLK _479_/D fanout89/X VPWR VGND sg13g2_dfrbpq_1
XFILLER_46_437 VPWR VGND sg13g2_decap_8
XFILLER_47_905 VPWR VGND sg13g2_decap_8
XFILLER_15_846 VPWR VGND sg13g2_decap_8
XFILLER_30_816 VPWR VGND sg13g2_fill_1
XFILLER_42_621 VPWR VGND sg13g2_decap_8
XFILLER_42_698 VPWR VGND sg13g2_decap_8
X_402_ _567_/D _566_/Q _567_/Q _405_/S VPWR VGND sg13g2_mux2_1
X_333_ _498_/D _497_/Q _498_/Q _348_/S VPWR VGND sg13g2_mux2_1
X_264_ _264_/X _618_/Q _266_/B VPWR VGND sg13g2_or2_1
XFILLER_6_577 VPWR VGND sg13g2_decap_8
XFILLER_6_522 VPWR VGND sg13g2_fill_1
XFILLER_2_772 VPWR VGND sg13g2_decap_8
XFILLER_49_275 VPWR VGND sg13g2_decap_8
XFILLER_21_805 VPWR VGND sg13g2_decap_8
XFILLER_45_492 VPWR VGND sg13g2_decap_8
XFILLER_14_890 VPWR VGND sg13g2_decap_8
XFILLER_43_407 VPWR VGND sg13g2_decap_8
XFILLER_46_17 VPWR VGND sg13g2_fill_1
XFILLER_12_816 VPWR VGND sg13g2_decap_8
XFILLER_4_1016 VPWR VGND sg13g2_decap_8
XFILLER_47_702 VPWR VGND sg13g2_decap_8
XFILLER_4_1027 VPWR VGND sg13g2_fill_2
XFILLER_47_779 VPWR VGND sg13g2_decap_8
XFILLER_42_484 VPWR VGND sg13g2_decap_4
X_316_ _481_/D _480_/Q _481_/Q _323_/S VPWR VGND sg13g2_mux2_1
X_247_ _247_/X _640_/Q _249_/B VPWR VGND sg13g2_and2_1
XFILLER_42_5 VPWR VGND sg13g2_fill_2
XFILLER_7_864 VPWR VGND sg13g2_decap_8
XFILLER_44_738 VPWR VGND sg13g2_decap_8
XFILLER_4_834 VPWR VGND sg13g2_decap_8
XFILLER_35_749 VPWR VGND sg13g2_decap_8
XFILLER_42_270 VPWR VGND sg13g2_decap_4
XFILLER_47_576 VPWR VGND sg13g2_decap_8
XFILLER_6_182 VPWR VGND sg13g2_decap_8
XFILLER_19_790 VPWR VGND sg13g2_decap_8
XFILLER_0_303 VPWR VGND sg13g2_fill_2
XFILLER_49_1028 VPWR VGND sg13g2_fill_1
XFILLER_49_1017 VPWR VGND sg13g2_decap_8
XFILLER_0_358 VPWR VGND sg13g2_decap_4
X_650_ _650_/Q _658_/CLK _650_/D fanout75/X VPWR VGND sg13g2_dfrbpq_1
XFILLER_17_749 VPWR VGND sg13g2_decap_8
XFILLER_44_535 VPWR VGND sg13g2_decap_8
X_581_ _581_/Q _608_/CLK _581_/D fanout71/X VPWR VGND sg13g2_dfrbpq_1
XFILLER_13_966 VPWR VGND sg13g2_decap_8
XFILLER_40_763 VPWR VGND sg13g2_decap_8
XFILLER_9_959 VPWR VGND sg13g2_decap_8
XFILLER_4_631 VPWR VGND sg13g2_decap_8
XFILLER_48_852 VPWR VGND sg13g2_decap_8
XFILLER_47_373 VPWR VGND sg13g2_decap_8
XFILLER_31_763 VPWR VGND sg13g2_decap_8
XFILLER_10_914 VPWR VGND sg13g2_decap_8
XFILLER_22_763 VPWR VGND sg13g2_decap_8
XFILLER_22_796 VPWR VGND sg13g2_decap_8
XFILLER_1_667 VPWR VGND sg13g2_decap_8
XFILLER_0_177 VPWR VGND sg13g2_decap_8
XFILLER_0_188 VPWR VGND sg13g2_fill_2
XFILLER_44_332 VPWR VGND sg13g2_fill_1
XFILLER_45_800 VPWR VGND sg13g2_decap_8
X_633_ _633_/Q _447_/Y _633_/D fanout70/X VPWR VGND sg13g2_dfrbpq_1
XFILLER_44_376 VPWR VGND sg13g2_decap_8
X_564_ _564_/Q _567_/CLK _564_/D fanout94/X VPWR VGND sg13g2_dfrbpq_1
X_495_ _495_/Q _514_/CLK _495_/D fanout96/X VPWR VGND sg13g2_dfrbpq_1
XFILLER_9_756 VPWR VGND sg13g2_decap_8
XFILLER_5_940 VPWR VGND sg13g2_decap_8
XFILLER_5_44 VPWR VGND sg13g2_fill_1
XFILLER_2_409 VPWR VGND sg13g2_fill_1
XFILLER_27_833 VPWR VGND sg13g2_decap_8
XFILLER_42_803 VPWR VGND sg13g2_decap_8
X_280_ _280_/X _280_/A0 _280_/A1 _456_/A _649_/Q _279_/B _281_/A VPWR VGND sg13g2_mux4_1
XFILLER_10_788 VPWR VGND sg13g2_decap_8
XFILLER_2_954 VPWR VGND sg13g2_decap_8
XFILLER_49_457 VPWR VGND sg13g2_decap_8
XFILLER_18_811 VPWR VGND sg13g2_decap_8
XFILLER_45_674 VPWR VGND sg13g2_decap_8
X_547_ _547_/Q _560_/CLK _547_/D fanout92/X VPWR VGND sg13g2_dfrbpq_1
X_616_ _616_/Q _620_/CLK _616_/D fanout66/X VPWR VGND sg13g2_dfrbpq_1
X_478_ _478_/Q _488_/CLK _478_/D fanout89/X VPWR VGND sg13g2_dfrbpq_1
XFILLER_49_991 VPWR VGND sg13g2_fill_1
XFILLER_24_847 VPWR VGND sg13g2_decap_4
XFILLER_13_1008 VPWR VGND sg13g2_decap_8
XFILLER_3_707 VPWR VGND sg13g2_decap_8
Xclkbuf_0_clk_regs clkbuf_0_clk_regs/X clkbuf_regs_0_clk/X VPWR VGND sg13g2_buf_16
XFILLER_2_239 VPWR VGND sg13g2_decap_4
XFILLER_15_825 VPWR VGND sg13g2_decap_8
XFILLER_42_600 VPWR VGND sg13g2_decap_8
XFILLER_46_416 VPWR VGND sg13g2_decap_8
X_401_ _566_/D _565_/Q _566_/Q _405_/S VPWR VGND sg13g2_mux2_1
XFILLER_42_677 VPWR VGND sg13g2_decap_8
X_332_ _497_/D _496_/Q _497_/Q _348_/S VPWR VGND sg13g2_mux2_1
X_263_ _645_/D _222_/Y _266_/A _262_/Y VPWR VGND sg13g2_o21ai_1
XFILLER_2_751 VPWR VGND sg13g2_decap_8
XFILLER_1_272 VPWR VGND sg13g2_decap_4
XFILLER_2_45 VPWR VGND sg13g2_fill_1
XFILLER_49_254 VPWR VGND sg13g2_decap_8
XFILLER_45_471 VPWR VGND sg13g2_decap_8
XFILLER_20_850 VPWR VGND sg13g2_fill_2
Xdelaybuf_1_clk delaybuf_2_clk/A _256_/B VPWR VGND sg13g2_buf_16
XFILLER_47_758 VPWR VGND sg13g2_decap_8
XFILLER_11_894 VPWR VGND sg13g2_decap_8
X_315_ _480_/D _479_/Q _480_/Q _323_/S VPWR VGND sg13g2_mux2_1
X_246_ _246_/X _639_/Q _249_/B VPWR VGND sg13g2_and2_1
XFILLER_7_843 VPWR VGND sg13g2_decap_8
XFILLER_0_529 VPWR VGND sg13g2_decap_8
XFILLER_37_791 VPWR VGND sg13g2_decap_8
XFILLER_44_717 VPWR VGND sg13g2_decap_8
XFILLER_3_378 VPWR VGND sg13g2_decap_8
XFILLER_4_813 VPWR VGND sg13g2_decap_8
XFILLER_47_555 VPWR VGND sg13g2_decap_8
XFILLER_28_791 VPWR VGND sg13g2_decap_8
X_229_ _467_/D _234_/A0 _655_/D _231_/S VPWR VGND sg13g2_mux2_1
XFILLER_7_684 VPWR VGND sg13g2_fill_1
XFILLER_7_673 VPWR VGND sg13g2_decap_8
XFILLER_6_161 VPWR VGND sg13g2_decap_8
XFILLER_1_849 VPWR VGND sg13g2_decap_8
X_580_ _607_/D _620_/CLK _580_/D fanout84/X VPWR VGND sg13g2_dfrbpq_1
XFILLER_13_945 VPWR VGND sg13g2_decap_8
XFILLER_25_794 VPWR VGND sg13g2_decap_8
XFILLER_9_938 VPWR VGND sg13g2_decap_8
XFILLER_4_610 VPWR VGND sg13g2_decap_8
XFILLER_0_893 VPWR VGND sg13g2_decap_8
XFILLER_4_687 VPWR VGND sg13g2_decap_8
XFILLER_16_761 VPWR VGND sg13g2_fill_2
XFILLER_48_831 VPWR VGND sg13g2_decap_8
XFILLER_47_352 VPWR VGND sg13g2_decap_8
XFILLER_8_993 VPWR VGND sg13g2_decap_8
XFILLER_5_429 VPWR VGND sg13g2_decap_8
XFILLER_5_407 VPWR VGND sg13g2_fill_2
XFILLER_1_646 VPWR VGND sg13g2_decap_8
XFILLER_49_639 VPWR VGND sg13g2_decap_8
X_563_ _563_/Q _575_/CLK _563_/D fanout93/X VPWR VGND sg13g2_dfrbpq_1
X_632_ _632_/Q _446_/Y _632_/D fanout70/X VPWR VGND sg13g2_dfrbpq_1
X_494_ _494_/Q _514_/CLK _494_/D fanout96/X VPWR VGND sg13g2_dfrbpq_1
XFILLER_5_996 VPWR VGND sg13g2_decap_8
XFILLER_0_690 VPWR VGND sg13g2_decap_8
XFILLER_36_812 VPWR VGND sg13g2_decap_8
XFILLER_8_790 VPWR VGND sg13g2_decap_8
XFILLER_27_812 VPWR VGND sg13g2_decap_8
XFILLER_2_933 VPWR VGND sg13g2_decap_8
XFILLER_6_749 VPWR VGND sg13g2_decap_8
XFILLER_49_436 VPWR VGND sg13g2_decap_8
XFILLER_18_845 VPWR VGND sg13g2_decap_8
XFILLER_33_837 VPWR VGND sg13g2_decap_8
XFILLER_45_653 VPWR VGND sg13g2_decap_8
X_546_ _546_/Q _560_/CLK _546_/D fanout92/X VPWR VGND sg13g2_dfrbpq_1
X_615_ _615_/Q _630_/CLK _615_/D fanout66/X VPWR VGND sg13g2_dfrbpq_1
Xu_multimode_dll VPWR VGND _514_/Q _280_/A0 _496_/Q _497_/Q _498_/Q _499_/Q _500_/Q
+ _282_/A1 _501_/Q _502_/Q _503_/Q _504_/Q _505_/Q _284_/A1 _506_/Q _507_/Q _508_/Q
+ _509_/Q _510_/Q _515_/Q ena _516_/Q _526_/Q _527_/Q _528_/Q _529_/Q _530_/Q _531_/Q
+ _532_/Q _533_/Q _534_/Q _535_/Q _517_/Q _536_/Q _537_/Q _538_/Q _539_/Q _540_/Q
+ _541_/Q _518_/Q _519_/Q _520_/Q _521_/Q _522_/Q _523_/Q _524_/Q _525_/Q _481_/Q
+ _482_/Q _483_/Q _484_/Q _485_/Q _486_/Q _487_/Q _488_/Q _489_/Q _490_/Q _491_/Q
+ _492_/Q _493_/Q _494_/Q _495_/Q _476_/Q _477_/Q _478_/Q _479_/Q _480_/Q _511_/Q
+ _512_/Q _513_/Q delaybuf_15_clk/X _288_/A1 fanout85/X _286_/A1 multimode_dll
X_477_ _477_/Q _488_/CLK _477_/D fanout89/X VPWR VGND sg13g2_dfrbpq_1
XFILLER_5_793 VPWR VGND sg13g2_decap_8
XFILLER_24_826 VPWR VGND sg13g2_decap_8
XFILLER_15_804 VPWR VGND sg13g2_decap_8
XFILLER_42_656 VPWR VGND sg13g2_decap_8
X_400_ _565_/D _564_/Q _565_/Q _405_/S VPWR VGND sg13g2_mux2_1
X_331_ _496_/D _495_/Q _496_/Q _410_/S VPWR VGND sg13g2_mux2_1
XFILLER_41_41 VPWR VGND sg13g2_fill_2
X_262_ _262_/Y _277_/S _617_/Q _618_/Q VPWR VGND sg13g2_nand3_1
XFILLER_2_730 VPWR VGND sg13g2_decap_8
XFILLER_49_233 VPWR VGND sg13g2_decap_8
XFILLER_45_450 VPWR VGND sg13g2_decap_8
X_529_ _529_/Q _541_/CLK _529_/D fanout76/X VPWR VGND sg13g2_dfrbpq_1
XFILLER_47_737 VPWR VGND sg13g2_decap_8
X_314_ _479_/D _478_/Q _479_/Q _323_/S VPWR VGND sg13g2_mux2_1
XFILLER_11_873 VPWR VGND sg13g2_decap_8
X_245_ _245_/X _638_/Q _249_/B VPWR VGND sg13g2_and2_1
XFILLER_7_899 VPWR VGND sg13g2_decap_8
XFILLER_7_822 VPWR VGND sg13g2_decap_8
XFILLER_46_781 VPWR VGND sg13g2_decap_8
XFILLER_0_508 VPWR VGND sg13g2_decap_8
XFILLER_37_770 VPWR VGND sg13g2_decap_8
XFILLER_3_357 VPWR VGND sg13g2_decap_4
XFILLER_4_869 VPWR VGND sg13g2_decap_8
XFILLER_28_770 VPWR VGND sg13g2_decap_8
XFILLER_47_534 VPWR VGND sg13g2_decap_8
XFILLER_43_784 VPWR VGND sg13g2_decap_8
X_228_ _468_/D _233_/A0 _656_/D _231_/S VPWR VGND sg13g2_mux2_1
XFILLER_7_652 VPWR VGND sg13g2_decap_8
XFILLER_34_784 VPWR VGND sg13g2_decap_8
XFILLER_1_828 VPWR VGND sg13g2_decap_8
XFILLER_13_924 VPWR VGND sg13g2_decap_8
XFILLER_25_773 VPWR VGND sg13g2_decap_8
XFILLER_9_917 VPWR VGND sg13g2_decap_8
XFILLER_40_798 VPWR VGND sg13g2_decap_8
XFILLER_4_666 VPWR VGND sg13g2_decap_8
XFILLER_0_872 VPWR VGND sg13g2_decap_8
XFILLER_48_810 VPWR VGND sg13g2_decap_8
XFILLER_16_784 VPWR VGND sg13g2_decap_8
XFILLER_48_887 VPWR VGND sg13g2_decap_8
XFILLER_31_798 VPWR VGND sg13g2_decap_8
XFILLER_43_581 VPWR VGND sg13g2_decap_8
Xclkbuf_4_2_0_clk_regs clkbuf_4_2_0_clk_regs/X clkbuf_0_clk_regs/X VPWR VGND sg13g2_buf_8
XFILLER_8_972 VPWR VGND sg13g2_decap_8
XFILLER_31_0 VPWR VGND sg13g2_fill_1
XFILLER_10_949 VPWR VGND sg13g2_decap_8
XFILLER_1_625 VPWR VGND sg13g2_decap_8
XFILLER_49_618 VPWR VGND sg13g2_decap_8
XFILLER_45_835 VPWR VGND sg13g2_decap_8
X_562_ _562_/Q _570_/CLK _562_/D fanout92/X VPWR VGND sg13g2_dfrbpq_1
X_631_ _631_/Q _445_/Y _631_/D fanout67/X VPWR VGND sg13g2_dfrbpq_1
X_493_ _493_/Q _574_/CLK _493_/D fanout96/X VPWR VGND sg13g2_dfrbpq_1
XFILLER_13_776 VPWR VGND sg13g2_fill_2
XFILLER_13_798 VPWR VGND sg13g2_decap_8
XFILLER_5_975 VPWR VGND sg13g2_decap_8
XFILLER_48_684 VPWR VGND sg13g2_decap_8
XFILLER_42_838 VPWR VGND sg13g2_decap_8
XFILLER_1_422 VPWR VGND sg13g2_decap_4
XFILLER_2_912 VPWR VGND sg13g2_decap_8
XFILLER_2_989 VPWR VGND sg13g2_decap_8
XFILLER_7_1027 VPWR VGND sg13g2_fill_2
XFILLER_49_415 VPWR VGND sg13g2_decap_8
XFILLER_45_632 VPWR VGND sg13g2_decap_8
X_545_ _545_/Q _569_/CLK _545_/D fanout95/X VPWR VGND sg13g2_dfrbpq_1
X_614_ _614_/Q _627_/CLK _614_/D fanout65/X VPWR VGND sg13g2_dfrbpq_1
X_476_ _476_/Q _652_/CLK _476_/D fanout79/X VPWR VGND sg13g2_dfrbpq_1
Xdelaybuf_20_clk delaybuf_21_clk/A delaybuf_20_clk/A VPWR VGND sg13g2_buf_16
XFILLER_5_772 VPWR VGND sg13g2_decap_8
XFILLER_24_805 VPWR VGND sg13g2_decap_8
XFILLER_48_481 VPWR VGND sg13g2_decap_8
Xdelaybuf_11_clk delaybuf_12_clk/A delaybuf_11_clk/A VPWR VGND sg13g2_buf_16
XFILLER_42_635 VPWR VGND sg13g2_decap_8
X_330_ _495_/D _494_/Q _495_/Q _407_/S VPWR VGND sg13g2_mux2_1
X_261_ _266_/B _277_/S _617_/Q VPWR VGND sg13g2_nand2_1
XFILLER_2_786 VPWR VGND sg13g2_decap_8
XFILLER_9_0 VPWR VGND sg13g2_fill_2
XFILLER_49_289 VPWR VGND sg13g2_decap_8
XFILLER_21_819 VPWR VGND sg13g2_decap_4
X_528_ _528_/Q _541_/CLK _528_/D fanout76/X VPWR VGND sg13g2_dfrbpq_1
X_459_ _459_/Y _459_/A _459_/B VPWR VGND sg13g2_xnor2_1
XFILLER_3_539 VPWR VGND sg13g2_decap_8
Xclkbuf_4_15_0_clk_regs clkbuf_4_15_0_clk_regs/X clkbuf_0_clk_regs/X VPWR VGND sg13g2_buf_8
XFILLER_46_237 VPWR VGND sg13g2_decap_8
XFILLER_46_248 VPWR VGND sg13g2_fill_1
XFILLER_47_716 VPWR VGND sg13g2_decap_8
XFILLER_11_852 VPWR VGND sg13g2_decap_8
X_313_ _478_/D _477_/Q _478_/Q _323_/S VPWR VGND sg13g2_mux2_1
X_244_ _244_/X _637_/Q _249_/B VPWR VGND sg13g2_and2_1
XFILLER_7_801 VPWR VGND sg13g2_decap_8
XFILLER_7_878 VPWR VGND sg13g2_decap_8
XFILLER_2_583 VPWR VGND sg13g2_decap_8
XFILLER_38_749 VPWR VGND sg13g2_decap_8
XFILLER_45_292 VPWR VGND sg13g2_decap_8
XFILLER_46_760 VPWR VGND sg13g2_decap_8
XFILLER_29_749 VPWR VGND sg13g2_decap_8
XFILLER_4_848 VPWR VGND sg13g2_decap_8
XFILLER_47_513 VPWR VGND sg13g2_decap_8
XFILLER_43_763 VPWR VGND sg13g2_decap_8
X_227_ _231_/S _648_/Q _647_/Q VPWR VGND sg13g2_nand2_1
XFILLER_7_631 VPWR VGND sg13g2_decap_8
XFILLER_6_196 VPWR VGND sg13g2_fill_2
XFILLER_6_141 VPWR VGND sg13g2_decap_8
XFILLER_34_763 VPWR VGND sg13g2_decap_8
XFILLER_1_807 VPWR VGND sg13g2_decap_8
XFILLER_25_752 VPWR VGND sg13g2_decap_8
XFILLER_44_549 VPWR VGND sg13g2_decap_8
XFILLER_13_903 VPWR VGND sg13g2_decap_8
XFILLER_40_777 VPWR VGND sg13g2_decap_8
XFILLER_4_645 VPWR VGND sg13g2_decap_8
XFILLER_0_851 VPWR VGND sg13g2_decap_8
XFILLER_48_866 VPWR VGND sg13g2_fill_2
XFILLER_16_763 VPWR VGND sg13g2_fill_1
XFILLER_43_560 VPWR VGND sg13g2_decap_8
XFILLER_47_387 VPWR VGND sg13g2_decap_8
XFILLER_12_991 VPWR VGND sg13g2_decap_8
XFILLER_31_777 VPWR VGND sg13g2_decap_8
XFILLER_8_951 VPWR VGND sg13g2_decap_8
XFILLER_7_483 VPWR VGND sg13g2_decap_8
XFILLER_39_833 VPWR VGND sg13g2_decap_8
XFILLER_10_928 VPWR VGND sg13g2_decap_8
XFILLER_22_777 VPWR VGND sg13g2_decap_4
XFILLER_1_604 VPWR VGND sg13g2_decap_8
X_630_ _630_/Q _630_/CLK _630_/D fanout66/X VPWR VGND sg13g2_dfrbpq_1
Xclkbuf_1_1__f_clk clkload0/A clkbuf_0_clk/X VPWR VGND sg13g2_buf_16
XFILLER_44_302 VPWR VGND sg13g2_fill_1
XFILLER_45_814 VPWR VGND sg13g2_decap_8
X_561_ _561_/Q _570_/CLK _561_/D fanout92/X VPWR VGND sg13g2_dfrbpq_1
X_492_ _492_/Q _514_/CLK _492_/D fanout86/X VPWR VGND sg13g2_dfrbpq_1
XFILLER_5_954 VPWR VGND sg13g2_decap_8
XFILLER_48_663 VPWR VGND sg13g2_decap_8
XFILLER_27_847 VPWR VGND sg13g2_decap_4
XFILLER_42_817 VPWR VGND sg13g2_decap_8
XFILLER_5_217 VPWR VGND sg13g2_decap_8
XFILLER_2_968 VPWR VGND sg13g2_decap_8
XFILLER_18_825 VPWR VGND sg13g2_fill_2
XFILLER_45_611 VPWR VGND sg13g2_decap_8
X_613_ _613_/Q _627_/CLK _613_/D fanout64/X VPWR VGND sg13g2_dfrbpq_1
XFILLER_33_806 VPWR VGND sg13g2_decap_8
XFILLER_41_850 VPWR VGND sg13g2_fill_2
XFILLER_45_688 VPWR VGND sg13g2_decap_8
X_544_ _544_/Q _568_/CLK _544_/D fanout95/X VPWR VGND sg13g2_dfrbpq_1
X_475_ _475_/Q _521_/CLK _475_/D fanout79/X VPWR VGND sg13g2_dfrbpq_1
XFILLER_5_751 VPWR VGND sg13g2_decap_8
XFILLER_48_460 VPWR VGND sg13g2_decap_8
XFILLER_15_839 VPWR VGND sg13g2_decap_8
XFILLER_42_614 VPWR VGND sg13g2_decap_8
X_260_ _266_/A _647_/D _603_/Q VPWR VGND sg13g2_nand2_1
Xdelaybuf_4_clk delaybuf_5_clk/A delaybuf_4_clk/A VPWR VGND sg13g2_buf_16
XFILLER_2_765 VPWR VGND sg13g2_decap_8
XFILLER_45_485 VPWR VGND sg13g2_decap_8
X_527_ _527_/Q _541_/CLK _527_/D fanout69/X VPWR VGND sg13g2_dfrbpq_1
XFILLER_49_268 VPWR VGND sg13g2_decap_8
XFILLER_14_883 VPWR VGND sg13g2_decap_8
X_458_ _458_/Y _460_/A _460_/B VPWR VGND sg13g2_xnor2_1
X_389_ _554_/D _553_/Q _554_/Q _391_/S VPWR VGND sg13g2_mux2_1
Xclkbuf_1_0__f__017__regs _257__99/A clkbuf_0__017__regs/X VPWR VGND sg13g2_buf_16
XFILLER_5_592 VPWR VGND sg13g2_decap_8
XFILLER_12_809 VPWR VGND sg13g2_decap_8
XFILLER_11_46 VPWR VGND sg13g2_fill_2
XFILLER_4_1009 VPWR VGND sg13g2_decap_8
XFILLER_11_831 VPWR VGND sg13g2_decap_8
XFILLER_42_477 VPWR VGND sg13g2_decap_8
XFILLER_42_488 VPWR VGND sg13g2_fill_1
X_312_ _477_/D _476_/Q _477_/Q _323_/S VPWR VGND sg13g2_mux2_1
X_243_ _243_/X _636_/Q _249_/B VPWR VGND sg13g2_and2_1
XFILLER_7_857 VPWR VGND sg13g2_decap_8
XFILLER_2_562 VPWR VGND sg13g2_decap_8
XFILLER_45_271 VPWR VGND sg13g2_decap_8
XFILLER_4_827 VPWR VGND sg13g2_decap_8
XFILLER_16_967 VPWR VGND sg13g2_fill_1
XFILLER_43_742 VPWR VGND sg13g2_decap_8
XFILLER_47_569 VPWR VGND sg13g2_decap_8
XFILLER_42_274 VPWR VGND sg13g2_fill_1
X_226_ _226_/Y _653_/Q VPWR VGND sg13g2_inv_1
XFILLER_7_610 VPWR VGND sg13g2_decap_8
XFILLER_6_153 VPWR VGND sg13g2_decap_4
XFILLER_6_120 VPWR VGND sg13g2_decap_8
XFILLER_3_882 VPWR VGND sg13g2_decap_8
XFILLER_6_175 VPWR VGND sg13g2_decap_8
XFILLER_19_783 VPWR VGND sg13g2_decap_8
XFILLER_46_591 VPWR VGND sg13g2_decap_8
XFILLER_13_959 VPWR VGND sg13g2_decap_8
XFILLER_40_756 VPWR VGND sg13g2_decap_8
XFILLER_0_830 VPWR VGND sg13g2_decap_8
XFILLER_4_624 VPWR VGND sg13g2_decap_8
Xclkbuf_2_1__f_clk_delayed _460_/A clkbuf_0_clk_delayed/X VPWR VGND sg13g2_buf_16
XFILLER_48_845 VPWR VGND sg13g2_decap_8
XFILLER_47_366 VPWR VGND sg13g2_decap_8
XFILLER_31_756 VPWR VGND sg13g2_decap_8
XFILLER_12_970 VPWR VGND sg13g2_decap_8
XFILLER_8_930 VPWR VGND sg13g2_decap_8
XFILLER_7_451 VPWR VGND sg13g2_decap_8
XFILLER_39_812 VPWR VGND sg13g2_decap_8
XFILLER_0_1012 VPWR VGND sg13g2_decap_8
XFILLER_10_907 VPWR VGND sg13g2_decap_8
XFILLER_22_756 VPWR VGND sg13g2_decap_8
XFILLER_0_159 VPWR VGND sg13g2_fill_1
X_560_ _560_/Q _560_/CLK _560_/D fanout93/X VPWR VGND sg13g2_dfrbpq_1
XFILLER_44_369 VPWR VGND sg13g2_decap_8
X_491_ _491_/Q _575_/CLK _491_/D fanout86/X VPWR VGND sg13g2_dfrbpq_1
XFILLER_9_749 VPWR VGND sg13g2_decap_8
XFILLER_5_933 VPWR VGND sg13g2_decap_8
XFILLER_5_59 VPWR VGND sg13g2_fill_2
XFILLER_36_826 VPWR VGND sg13g2_decap_4
XFILLER_36_848 VPWR VGND sg13g2_decap_4
XFILLER_48_642 VPWR VGND sg13g2_decap_8
XFILLER_2_947 VPWR VGND sg13g2_decap_8
XFILLER_18_804 VPWR VGND sg13g2_decap_8
XFILLER_45_667 VPWR VGND sg13g2_decap_8
X_543_ _543_/Q _567_/CLK _543_/D fanout95/X VPWR VGND sg13g2_dfrbpq_1
X_612_ _612_/Q _612_/CLK _612_/D fanout68/X VPWR VGND sg13g2_dfrbpq_1
X_474_ _474_/Q _660_/CLK _474_/D fanout78/X VPWR VGND sg13g2_dfrbpq_1
XFILLER_5_730 VPWR VGND sg13g2_decap_8
XFILLER_49_940 VPWR VGND sg13g2_decap_8
XFILLER_32_851 VPWR VGND sg13g2_fill_1
XFILLER_15_818 VPWR VGND sg13g2_decap_8
XFILLER_46_409 VPWR VGND sg13g2_decap_8
XFILLER_23_851 VPWR VGND sg13g2_fill_1
XFILLER_25_45 VPWR VGND sg13g2_fill_1
XFILLER_1_243 VPWR VGND sg13g2_fill_2
XFILLER_2_744 VPWR VGND sg13g2_decap_8
XFILLER_49_247 VPWR VGND sg13g2_decap_8
XFILLER_45_464 VPWR VGND sg13g2_decap_8
X_526_ _526_/Q _655_/CLK _526_/D fanout68/X VPWR VGND sg13g2_dfrbpq_1
XFILLER_12_1012 VPWR VGND sg13g2_decap_8
XFILLER_14_862 VPWR VGND sg13g2_decap_8
X_457_ _457_/Y _460_/A _460_/B VPWR VGND sg13g2_xnor2_1
X_388_ _553_/D _552_/Q _553_/Q _391_/S VPWR VGND sg13g2_mux2_1
XFILLER_5_571 VPWR VGND sg13g2_decap_8
XFILLER_11_810 VPWR VGND sg13g2_decap_8
XFILLER_11_887 VPWR VGND sg13g2_decap_8
X_311_ _476_/D _476_/Q input3/X _311_/S VPWR VGND sg13g2_mux2_1
X_242_ _242_/X _635_/Q _249_/B VPWR VGND sg13g2_and2_1
XFILLER_7_836 VPWR VGND sg13g2_decap_8
XFILLER_2_541 VPWR VGND sg13g2_decap_8
XFILLER_45_250 VPWR VGND sg13g2_decap_8
X_509_ _509_/Q _622_/CLK _509_/D fanout84/X VPWR VGND sg13g2_dfrbpq_1
XFILLER_46_795 VPWR VGND sg13g2_decap_8
XFILLER_37_784 VPWR VGND sg13g2_decap_8
XFILLER_22_35 VPWR VGND sg13g2_fill_1
XFILLER_3_305 VPWR VGND sg13g2_decap_4
XFILLER_4_806 VPWR VGND sg13g2_decap_8
XFILLER_47_548 VPWR VGND sg13g2_decap_8
XFILLER_28_784 VPWR VGND sg13g2_decap_8
XFILLER_43_721 VPWR VGND sg13g2_decap_8
XFILLER_43_798 VPWR VGND sg13g2_decap_8
X_225_ _225_/Y _652_/Q VPWR VGND sg13g2_inv_1
XFILLER_8_37 VPWR VGND sg13g2_fill_1
XFILLER_7_666 VPWR VGND sg13g2_decap_8
XFILLER_3_861 VPWR VGND sg13g2_decap_8
XFILLER_46_570 VPWR VGND sg13g2_decap_8
XFILLER_34_798 VPWR VGND sg13g2_decap_8
XFILLER_13_938 VPWR VGND sg13g2_decap_8
XFILLER_25_787 VPWR VGND sg13g2_decap_8
XFILLER_4_603 VPWR VGND sg13g2_decap_8
XFILLER_0_886 VPWR VGND sg13g2_decap_8
XFILLER_48_868 VPWR VGND sg13g2_fill_1
XFILLER_48_824 VPWR VGND sg13g2_decap_8
XFILLER_47_345 VPWR VGND sg13g2_decap_8
XFILLER_47_312 VPWR VGND sg13g2_fill_1
XFILLER_16_754 VPWR VGND sg13g2_decap_8
XFILLER_16_798 VPWR VGND sg13g2_decap_8
XFILLER_43_595 VPWR VGND sg13g2_decap_8
XFILLER_8_986 VPWR VGND sg13g2_decap_8
XFILLER_48_1022 VPWR VGND sg13g2_decap_8
XFILLER_0_105 VPWR VGND sg13g2_fill_2
XFILLER_1_639 VPWR VGND sg13g2_decap_8
XFILLER_45_849 VPWR VGND sg13g2_fill_2
X_490_ _490_/Q _513_/CLK _490_/D fanout87/X VPWR VGND sg13g2_dfrbpq_1
XFILLER_5_989 VPWR VGND sg13g2_decap_8
XFILLER_5_912 VPWR VGND sg13g2_decap_8
XFILLER_0_683 VPWR VGND sg13g2_decap_8
XFILLER_48_621 VPWR VGND sg13g2_decap_8
XFILLER_36_805 VPWR VGND sg13g2_decap_8
XFILLER_48_698 VPWR VGND sg13g2_decap_8
XFILLER_8_783 VPWR VGND sg13g2_decap_8
Xdelaybuf_23_clk delaybuf_24_clk/A clk VPWR VGND sg13g2_buf_16
XFILLER_7_293 VPWR VGND sg13g2_decap_8
XFILLER_27_805 VPWR VGND sg13g2_decap_8
XFILLER_2_926 VPWR VGND sg13g2_decap_8
Xclkbuf_4_1_0_clk_regs clkbuf_4_1_0_clk_regs/X clkbuf_0_clk_regs/X VPWR VGND sg13g2_buf_8
Xdelaybuf_14_clk delaybuf_14_clk/X delaybuf_14_clk/A VPWR VGND sg13g2_buf_16
XFILLER_49_429 VPWR VGND sg13g2_decap_8
XFILLER_18_827 VPWR VGND sg13g2_fill_1
XFILLER_18_838 VPWR VGND sg13g2_decap_8
XFILLER_45_646 VPWR VGND sg13g2_decap_8
X_542_ _542_/Q _575_/CLK _542_/D fanout93/X VPWR VGND sg13g2_dfrbpq_1
X_611_ _611_/Q _655_/CLK _611_/D fanout69/X VPWR VGND sg13g2_dfrbpq_1
X_473_ _473_/Q _660_/CLK _473_/D fanout78/X VPWR VGND sg13g2_dfrbpq_1
XFILLER_5_786 VPWR VGND sg13g2_decap_8
XFILLER_48_495 VPWR VGND sg13g2_decap_8
XFILLER_24_819 VPWR VGND sg13g2_decap_8
XFILLER_23_830 VPWR VGND sg13g2_decap_8
XFILLER_42_649 VPWR VGND sg13g2_decap_8
XFILLER_2_723 VPWR VGND sg13g2_decap_8
XFILLER_49_226 VPWR VGND sg13g2_decap_8
XFILLER_14_841 VPWR VGND sg13g2_decap_8
XFILLER_45_443 VPWR VGND sg13g2_decap_8
X_525_ _525_/Q _624_/CLK _525_/D fanout68/X VPWR VGND sg13g2_dfrbpq_1
X_456_ _456_/Y _456_/A _456_/B VPWR VGND sg13g2_xnor2_1
XFILLER_41_682 VPWR VGND sg13g2_decap_8
X_387_ _552_/D _551_/Q _552_/Q _405_/S VPWR VGND sg13g2_mux2_1
XFILLER_5_550 VPWR VGND sg13g2_decap_8
XFILLER_49_793 VPWR VGND sg13g2_decap_8
XFILLER_48_292 VPWR VGND sg13g2_decap_8
X_310_ _475_/D _475_/Q _310_/B VPWR VGND sg13g2_xnor2_1
XFILLER_11_866 VPWR VGND sg13g2_decap_8
X_241_ _241_/X _656_/Q _253_/B VPWR VGND sg13g2_and2_1
XFILLER_7_815 VPWR VGND sg13g2_decap_8
XFILLER_2_520 VPWR VGND sg13g2_decap_8
XFILLER_2_597 VPWR VGND sg13g2_decap_8
XFILLER_7_0 VPWR VGND sg13g2_fill_2
XFILLER_46_774 VPWR VGND sg13g2_decap_8
X_508_ _508_/Q _608_/CLK _508_/D fanout71/X VPWR VGND sg13g2_dfrbpq_1
X_439_ _439_/Y _460_/A _444_/B VPWR VGND sg13g2_xnor2_1
XFILLER_37_763 VPWR VGND sg13g2_decap_8
XFILLER_3_1022 VPWR VGND sg13g2_decap_8
XFILLER_49_590 VPWR VGND sg13g2_decap_8
XFILLER_28_763 VPWR VGND sg13g2_decap_8
XFILLER_43_700 VPWR VGND sg13g2_decap_8
XFILLER_47_527 VPWR VGND sg13g2_decap_8
XFILLER_43_777 VPWR VGND sg13g2_decap_8
X_224_ _224_/Y _651_/Q VPWR VGND sg13g2_inv_1
XFILLER_3_840 VPWR VGND sg13g2_decap_8
XFILLER_7_645 VPWR VGND sg13g2_decap_8
XFILLER_19_752 VPWR VGND sg13g2_decap_4
XFILLER_34_777 VPWR VGND sg13g2_decap_8
Xclkbuf_4_14_0_clk_regs clkbuf_4_14_0_clk_regs/X clkbuf_0_clk_regs/X VPWR VGND sg13g2_buf_8
XFILLER_13_917 VPWR VGND sg13g2_decap_8
XFILLER_25_766 VPWR VGND sg13g2_decap_8
XFILLER_3_125 VPWR VGND sg13g2_fill_2
XFILLER_4_659 VPWR VGND sg13g2_decap_8
XFILLER_0_865 VPWR VGND sg13g2_decap_8
XFILLER_48_803 VPWR VGND sg13g2_decap_8
XFILLER_16_777 VPWR VGND sg13g2_decap_8
XFILLER_43_574 VPWR VGND sg13g2_decap_8
XFILLER_8_965 VPWR VGND sg13g2_decap_8
XFILLER_7_420 VPWR VGND sg13g2_decap_8
XFILLER_7_497 VPWR VGND sg13g2_decap_8
XFILLER_39_847 VPWR VGND sg13g2_decap_4
Xclkbuf_leaf_2_clk _460_/B delaybuf_14_clk/X VPWR VGND sg13g2_buf_8
XFILLER_47_891 VPWR VGND sg13g2_decap_8
XFILLER_1_618 VPWR VGND sg13g2_decap_8
XFILLER_28_13 VPWR VGND sg13g2_fill_2
XFILLER_45_828 VPWR VGND sg13g2_decap_8
XFILLER_21_791 VPWR VGND sg13g2_decap_8
XFILLER_5_968 VPWR VGND sg13g2_decap_8
XFILLER_4_478 VPWR VGND sg13g2_decap_8
XFILLER_0_662 VPWR VGND sg13g2_decap_8
XFILLER_48_677 VPWR VGND sg13g2_decap_8
XFILLER_48_600 VPWR VGND sg13g2_decap_8
XFILLER_43_393 VPWR VGND sg13g2_decap_8
XFILLER_44_850 VPWR VGND sg13g2_fill_2
XFILLER_15_1022 VPWR VGND sg13g2_decap_8
XFILLER_8_762 VPWR VGND sg13g2_decap_8
Xu_custom_cells.u_final_mux.SwitchMatrixMultiplexer_inv_inst _577_/Q _284_/B2 VPWR
+ _288_/B2 _280_/A1 VGND _575_/Q SwitchMatrixMultiplexer_inv
XFILLER_2_905 VPWR VGND sg13g2_decap_8
X_610_ _610_/Q _624_/CLK _610_/D fanout68/X VPWR VGND sg13g2_dfrbpq_1
XFILLER_49_408 VPWR VGND sg13g2_decap_8
XFILLER_45_625 VPWR VGND sg13g2_decap_8
X_541_ _541_/Q _541_/CLK _541_/D fanout69/X VPWR VGND sg13g2_dfrbpq_1
X_472_ _472_/Q _521_/CLK _472_/D fanout79/X VPWR VGND sg13g2_dfrbpq_1
Xdelaybuf_7_clk _442_/B delaybuf_7_clk/A VPWR VGND sg13g2_buf_16
XFILLER_5_765 VPWR VGND sg13g2_decap_8
XFILLER_1_982 VPWR VGND sg13g2_decap_8
XFILLER_48_474 VPWR VGND sg13g2_decap_8
Xu_custom_cells.u_mux1.mux_inv_inst _286_/B2 VPWR VGND _574_/Q _573_/Q _572_/Q mux_inv
XFILLER_42_628 VPWR VGND sg13g2_decap_8
XFILLER_2_702 VPWR VGND sg13g2_decap_8
XFILLER_2_779 VPWR VGND sg13g2_decap_8
XFILLER_45_422 VPWR VGND sg13g2_decap_8
XFILLER_14_820 VPWR VGND sg13g2_decap_8
XFILLER_14_897 VPWR VGND sg13g2_decap_8
XFILLER_41_661 VPWR VGND sg13g2_decap_8
XFILLER_45_499 VPWR VGND sg13g2_decap_8
X_524_ _524_/Q _612_/CLK _524_/D fanout65/X VPWR VGND sg13g2_dfrbpq_1
X_455_ _455_/Y _456_/A _455_/B VPWR VGND sg13g2_xnor2_1
X_386_ _551_/D _550_/Q _551_/Q _398_/S VPWR VGND sg13g2_mux2_1
XFILLER_49_5 VPWR VGND sg13g2_fill_2
XFILLER_49_772 VPWR VGND sg13g2_decap_8
XFILLER_20_823 VPWR VGND sg13g2_decap_4
XFILLER_47_709 VPWR VGND sg13g2_decap_8
X_240_ _240_/X _655_/Q _253_/B VPWR VGND sg13g2_and2_1
XFILLER_11_845 VPWR VGND sg13g2_decap_8
XFILLER_2_576 VPWR VGND sg13g2_decap_8
XFILLER_45_285 VPWR VGND sg13g2_decap_8
XFILLER_46_753 VPWR VGND sg13g2_decap_8
X_507_ _507_/Q _608_/CLK _507_/D fanout71/X VPWR VGND sg13g2_dfrbpq_1
X_438_ _438_/Y _459_/A _442_/B VPWR VGND sg13g2_xnor2_1
X_369_ _534_/D _533_/Q _534_/Q _369_/S VPWR VGND sg13g2_mux2_1
XFILLER_6_882 VPWR VGND sg13g2_decap_8
XFILLER_3_1001 VPWR VGND sg13g2_decap_8
XFILLER_16_926 VPWR VGND sg13g2_decap_8
XFILLER_47_506 VPWR VGND sg13g2_decap_8
XFILLER_43_756 VPWR VGND sg13g2_decap_8
X_223_ _223_/Y _650_/Q VPWR VGND sg13g2_inv_1
XFILLER_7_624 VPWR VGND sg13g2_decap_8
XFILLER_6_189 VPWR VGND sg13g2_decap_8
XFILLER_6_134 VPWR VGND sg13g2_decap_8
XFILLER_2_395 VPWR VGND sg13g2_decap_8
XFILLER_3_896 VPWR VGND sg13g2_decap_8
XFILLER_19_797 VPWR VGND sg13g2_decap_8
XFILLER_34_756 VPWR VGND sg13g2_decap_8
XFILLER_4_638 VPWR VGND sg13g2_decap_8
XFILLER_0_844 VPWR VGND sg13g2_decap_8
Xu_clkbuf_analog_pin2.u_buf analog_pin2 _460_/A VPWR VGND sg13g2_buf_16
XFILLER_48_859 VPWR VGND sg13g2_decap_8
XFILLER_43_553 VPWR VGND sg13g2_decap_8
XFILLER_12_984 VPWR VGND sg13g2_decap_8
XFILLER_8_944 VPWR VGND sg13g2_decap_8
XFILLER_7_476 VPWR VGND sg13g2_decap_8
XFILLER_7_465 VPWR VGND sg13g2_fill_1
XFILLER_3_693 VPWR VGND sg13g2_decap_8
XFILLER_0_1026 VPWR VGND sg13g2_fill_2
XFILLER_39_826 VPWR VGND sg13g2_decap_8
XFILLER_0_73 VPWR VGND sg13g2_fill_1
XFILLER_30_770 VPWR VGND sg13g2_decap_8
XFILLER_0_107 VPWR VGND sg13g2_fill_1
XFILLER_44_328 VPWR VGND sg13g2_decap_4
XFILLER_45_807 VPWR VGND sg13g2_decap_8
XFILLER_21_770 VPWR VGND sg13g2_decap_8
XFILLER_5_947 VPWR VGND sg13g2_decap_8
XFILLER_0_641 VPWR VGND sg13g2_decap_8
XFILLER_48_656 VPWR VGND sg13g2_decap_8
XFILLER_15_1001 VPWR VGND sg13g2_decap_8
XFILLER_12_781 VPWR VGND sg13g2_decap_8
XFILLER_15_0 VPWR VGND sg13g2_fill_2
XFILLER_35_851 VPWR VGND sg13g2_fill_1
XFILLER_14_27 VPWR VGND sg13g2_fill_1
Xu_custom_cells.u_latch0.latch_inst _284_/B2 _282_/B2 VGND VPWR _577_/Q latch
XFILLER_30_59 VPWR VGND sg13g2_fill_1
XFILLER_18_818 VPWR VGND sg13g2_decap_8
XFILLER_45_604 VPWR VGND sg13g2_decap_8
X_540_ _540_/Q _655_/CLK _540_/D fanout69/X VPWR VGND sg13g2_dfrbpq_1
XFILLER_26_851 VPWR VGND sg13g2_fill_1
XFILLER_41_843 VPWR VGND sg13g2_decap_8
X_471_ _471_/Q _521_/CLK _471_/D fanout81/X VPWR VGND sg13g2_dfrbpq_1
XFILLER_5_744 VPWR VGND sg13g2_decap_8
XFILLER_1_961 VPWR VGND sg13g2_decap_8
XFILLER_49_987 VPWR VGND sg13g2_decap_4
XFILLER_48_453 VPWR VGND sg13g2_decap_8
XFILLER_42_607 VPWR VGND sg13g2_decap_8
XFILLER_2_758 VPWR VGND sg13g2_decap_8
XFILLER_45_401 VPWR VGND sg13g2_decap_8
XFILLER_45_478 VPWR VGND sg13g2_decap_8
X_523_ _523_/Q _609_/CLK _523_/D fanout67/X VPWR VGND sg13g2_dfrbpq_1
XFILLER_14_876 VPWR VGND sg13g2_decap_8
XFILLER_41_640 VPWR VGND sg13g2_decap_8
X_454_ _454_/Y _456_/A _456_/B VPWR VGND sg13g2_xnor2_1
X_385_ _550_/D _549_/Q _550_/Q _398_/S VPWR VGND sg13g2_mux2_1
XFILLER_12_1026 VPWR VGND sg13g2_fill_2
XFILLER_5_585 VPWR VGND sg13g2_decap_8
XFILLER_49_751 VPWR VGND sg13g2_decap_8
XFILLER_20_802 VPWR VGND sg13g2_decap_8
XFILLER_20_846 VPWR VGND sg13g2_decap_4
XFILLER_11_824 VPWR VGND sg13g2_decap_8
XFILLER_2_555 VPWR VGND sg13g2_decap_8
XFILLER_7_2 VPWR VGND sg13g2_fill_1
XFILLER_45_264 VPWR VGND sg13g2_decap_8
X_506_ _506_/Q _506_/CLK _506_/D fanout85/X VPWR VGND sg13g2_dfrbpq_1
XFILLER_46_732 VPWR VGND sg13g2_decap_8
X_437_ _602_/D _291_/B _295_/Y _602_/Q VPWR VGND sg13g2_a21o_1
X_368_ _533_/D _532_/Q _533_/Q _370_/S VPWR VGND sg13g2_mux2_1
X_299_ _300_/B _218_/Y _297_/B _304_/A VPWR VGND sg13g2_o21ai_1
XFILLER_6_861 VPWR VGND sg13g2_decap_8
XFILLER_37_798 VPWR VGND sg13g2_decap_8
XFILLER_28_798 VPWR VGND sg13g2_decap_8
XFILLER_43_735 VPWR VGND sg13g2_decap_8
X_222_ _222_/Y _604_/Q VPWR VGND sg13g2_inv_1
XFILLER_7_603 VPWR VGND sg13g2_decap_8
XFILLER_6_113 VPWR VGND sg13g2_decap_8
XFILLER_12_71 VPWR VGND sg13g2_fill_2
XFILLER_2_363 VPWR VGND sg13g2_decap_4
XFILLER_3_875 VPWR VGND sg13g2_decap_8
XFILLER_6_168 VPWR VGND sg13g2_decap_8
XFILLER_46_584 VPWR VGND sg13g2_decap_8
XFILLER_6_691 VPWR VGND sg13g2_fill_1
XFILLER_40_749 VPWR VGND sg13g2_decap_8
XFILLER_0_823 VPWR VGND sg13g2_decap_8
XFILLER_4_617 VPWR VGND sg13g2_decap_8
XFILLER_48_838 VPWR VGND sg13g2_decap_8
XFILLER_47_359 VPWR VGND sg13g2_decap_8
XFILLER_31_749 VPWR VGND sg13g2_decap_8
XFILLER_12_963 VPWR VGND sg13g2_decap_8
XFILLER_8_923 VPWR VGND sg13g2_decap_8
XFILLER_2_193 VPWR VGND sg13g2_decap_8
XFILLER_39_805 VPWR VGND sg13g2_decap_8
XFILLER_3_672 VPWR VGND sg13g2_decap_8
XFILLER_0_1005 VPWR VGND sg13g2_decap_8
XFILLER_46_381 VPWR VGND sg13g2_decap_8
XFILLER_15_790 VPWR VGND sg13g2_decap_8
XFILLER_22_749 VPWR VGND sg13g2_decap_8
Xdelaybuf_26_clk delaybuf_27_clk/A delaybuf_26_clk/A VPWR VGND sg13g2_buf_16
XFILLER_13_749 VPWR VGND sg13g2_fill_2
XFILLER_5_926 VPWR VGND sg13g2_decap_8
XFILLER_0_620 VPWR VGND sg13g2_decap_8
Xdelaybuf_17_clk delaybuf_18_clk/A delaybuf_17_clk/A VPWR VGND sg13g2_buf_16
XFILLER_4_447 VPWR VGND sg13g2_decap_4
XFILLER_0_697 VPWR VGND sg13g2_decap_8
XFILLER_36_819 VPWR VGND sg13g2_decap_8
XFILLER_48_635 VPWR VGND sg13g2_decap_8
XFILLER_43_340 VPWR VGND sg13g2_fill_2
XFILLER_8_797 VPWR VGND sg13g2_decap_8
XFILLER_4_981 VPWR VGND sg13g2_decap_8
XFILLER_27_819 VPWR VGND sg13g2_decap_4
Xu_clkbuf_analog_pin1.u_buf analog_pin1 _282_/A1 VPWR VGND sg13g2_buf_16
XFILLER_26_830 VPWR VGND sg13g2_decap_8
XFILLER_41_822 VPWR VGND sg13g2_decap_8
X_470_ _470_/Q _535_/CLK _470_/D fanout79/X VPWR VGND sg13g2_dfrbpq_1
XFILLER_0_494 VPWR VGND sg13g2_decap_8
XFILLER_1_940 VPWR VGND sg13g2_decap_8
XFILLER_4_277 VPWR VGND sg13g2_fill_2
XFILLER_49_933 VPWR VGND sg13g2_decap_8
XFILLER_48_432 VPWR VGND sg13g2_decap_8
XFILLER_44_682 VPWR VGND sg13g2_decap_8
X_599_ _599_/Q _609_/CLK _599_/D fanout64/X VPWR VGND sg13g2_dfrbpq_1
XFILLER_6_1022 VPWR VGND sg13g2_decap_8
XFILLER_23_844 VPWR VGND sg13g2_decap_8
XFILLER_2_737 VPWR VGND sg13g2_decap_8
XFILLER_45_457 VPWR VGND sg13g2_decap_8
X_522_ _522_/Q _535_/CLK _522_/D fanout81/X VPWR VGND sg13g2_dfrbpq_1
X_453_ _453_/Y _456_/A _456_/B VPWR VGND sg13g2_xnor2_1
XFILLER_12_1005 VPWR VGND sg13g2_decap_8
XFILLER_14_855 VPWR VGND sg13g2_decap_8
XFILLER_41_696 VPWR VGND sg13g2_decap_8
X_384_ _549_/D _548_/Q _549_/Q _397_/S VPWR VGND sg13g2_mux2_1
XFILLER_5_564 VPWR VGND sg13g2_decap_8
XFILLER_49_730 VPWR VGND sg13g2_decap_8
Xclkbuf_4_0_0_clk_regs clkbuf_4_0_0_clk_regs/X clkbuf_0_clk_regs/X VPWR VGND sg13g2_buf_8
XFILLER_11_803 VPWR VGND sg13g2_decap_8
XFILLER_7_829 VPWR VGND sg13g2_decap_8
XFILLER_2_534 VPWR VGND sg13g2_decap_8
XFILLER_6_339 VPWR VGND sg13g2_decap_8
XFILLER_46_711 VPWR VGND sg13g2_decap_8
XFILLER_45_243 VPWR VGND sg13g2_decap_8
X_505_ _505_/Q _578_/CLK _505_/D fanout85/X VPWR VGND sg13g2_dfrbpq_1
X_436_ _601_/D _600_/Q _601_/Q _436_/S VPWR VGND sg13g2_mux2_1
XFILLER_46_788 VPWR VGND sg13g2_decap_8
X_367_ _532_/D _531_/Q _532_/Q _370_/S VPWR VGND sg13g2_mux2_1
X_298_ _302_/B _469_/Q _470_/Q _311_/S VPWR VGND sg13g2_nand3_1
XFILLER_6_840 VPWR VGND sg13g2_decap_8
XFILLER_37_777 VPWR VGND sg13g2_decap_8
XFILLER_3_309 VPWR VGND sg13g2_fill_1
XFILLER_28_777 VPWR VGND sg13g2_decap_8
XFILLER_43_714 VPWR VGND sg13g2_decap_8
X_221_ _647_/D _277_/S VPWR VGND sg13g2_inv_1
XFILLER_7_659 VPWR VGND sg13g2_decap_8
XFILLER_3_854 VPWR VGND sg13g2_decap_8
XFILLER_46_563 VPWR VGND sg13g2_decap_8
XFILLER_15_994 VPWR VGND sg13g2_decap_8
X_419_ _584_/D _610_/D _584_/Q _419_/S VPWR VGND sg13g2_mux2_1
XFILLER_5_180 VPWR VGND sg13g2_fill_1
Xclkbuf_leaf_5_clk _455_/B clkbuf_leaf_6_clk/A VPWR VGND sg13g2_buf_8
XFILLER_33_791 VPWR VGND sg13g2_decap_4
Xclkbuf_5_19__f_clk_regs _622_/CLK clkbuf_4_9_0_clk_regs/X VPWR VGND sg13g2_buf_16
XFILLER_0_802 VPWR VGND sg13g2_decap_8
XFILLER_0_879 VPWR VGND sg13g2_decap_8
XFILLER_48_817 VPWR VGND sg13g2_decap_8
XFILLER_47_338 VPWR VGND sg13g2_decap_8
XFILLER_47_305 VPWR VGND sg13g2_decap_8
XFILLER_12_942 VPWR VGND sg13g2_decap_8
XFILLER_24_791 VPWR VGND sg13g2_decap_8
XFILLER_43_588 VPWR VGND sg13g2_decap_8
XFILLER_8_902 VPWR VGND sg13g2_decap_8
XFILLER_8_979 VPWR VGND sg13g2_decap_8
XFILLER_7_434 VPWR VGND sg13g2_fill_2
XFILLER_48_1015 VPWR VGND sg13g2_decap_8
XFILLER_2_161 VPWR VGND sg13g2_decap_4
XFILLER_3_651 VPWR VGND sg13g2_decap_8
XFILLER_0_1028 VPWR VGND sg13g2_fill_1
XFILLER_46_360 VPWR VGND sg13g2_decap_8
XFILLER_7_990 VPWR VGND sg13g2_decap_8
XFILLER_5_905 VPWR VGND sg13g2_decap_8
XFILLER_0_676 VPWR VGND sg13g2_decap_8
Xclkbuf_4_13_0_clk_regs clkbuf_4_13_0_clk_regs/X clkbuf_0_clk_regs/X VPWR VGND sg13g2_buf_8
XFILLER_48_614 VPWR VGND sg13g2_decap_8
XFILLER_3_481 VPWR VGND sg13g2_fill_1
XFILLER_8_776 VPWR VGND sg13g2_decap_8
XFILLER_7_264 VPWR VGND sg13g2_fill_1
XFILLER_4_960 VPWR VGND sg13g2_decap_8
XFILLER_3_492 VPWR VGND sg13g2_decap_8
XFILLER_2_919 VPWR VGND sg13g2_decap_8
XFILLER_41_801 VPWR VGND sg13g2_decap_8
XFILLER_45_639 VPWR VGND sg13g2_decap_8
XFILLER_5_779 VPWR VGND sg13g2_decap_8
XFILLER_4_267 VPWR VGND sg13g2_fill_2
XFILLER_1_996 VPWR VGND sg13g2_decap_8
XFILLER_49_912 VPWR VGND sg13g2_decap_8
XFILLER_48_411 VPWR VGND sg13g2_decap_8
XFILLER_44_661 VPWR VGND sg13g2_decap_8
X_598_ _598_/Q _629_/CLK _598_/D fanout64/X VPWR VGND sg13g2_dfrbpq_1
XFILLER_48_488 VPWR VGND sg13g2_decap_8
XANTENNA_1 ena VPWR VGND sg13g2_antennanp
XFILLER_6_1001 VPWR VGND sg13g2_decap_8
XFILLER_23_823 VPWR VGND sg13g2_decap_8
XFILLER_2_716 VPWR VGND sg13g2_decap_8
XFILLER_9_7 VPWR VGND sg13g2_fill_2
XFILLER_14_834 VPWR VGND sg13g2_decap_8
XFILLER_45_436 VPWR VGND sg13g2_decap_8
X_521_ _521_/Q _521_/CLK _521_/D fanout81/X VPWR VGND sg13g2_dfrbpq_1
X_452_ _452_/Y _452_/A _455_/B VPWR VGND sg13g2_xnor2_1
X_383_ _548_/D _547_/Q _548_/Q _397_/S VPWR VGND sg13g2_mux2_1
XFILLER_12_1028 VPWR VGND sg13g2_fill_1
XFILLER_41_675 VPWR VGND sg13g2_decap_8
Xu_clkbuf_analog_pin0.u_buf analog_pin0 _280_/A0 VPWR VGND sg13g2_buf_16
XFILLER_5_543 VPWR VGND sg13g2_decap_8
XFILLER_1_793 VPWR VGND sg13g2_decap_8
XFILLER_49_786 VPWR VGND sg13g2_decap_8
XFILLER_48_285 VPWR VGND sg13g2_decap_8
XFILLER_9_882 VPWR VGND sg13g2_decap_8
XFILLER_42_439 VPWR VGND sg13g2_decap_4
XFILLER_11_859 VPWR VGND sg13g2_decap_8
XFILLER_7_808 VPWR VGND sg13g2_decap_8
XFILLER_2_513 VPWR VGND sg13g2_decap_8
XFILLER_46_767 VPWR VGND sg13g2_decap_8
XFILLER_45_299 VPWR VGND sg13g2_decap_8
X_504_ _504_/Q _578_/CLK _504_/D fanout85/X VPWR VGND sg13g2_dfrbpq_1
X_435_ _600_/D _599_/Q _600_/Q _435_/S VPWR VGND sg13g2_mux2_1
X_366_ _531_/D _530_/Q _531_/Q _369_/S VPWR VGND sg13g2_mux2_1
X_297_ _469_/D _469_/Q _297_/B VPWR VGND sg13g2_xnor2_1
XFILLER_6_896 VPWR VGND sg13g2_decap_8
XFILLER_1_590 VPWR VGND sg13g2_decap_8
XFILLER_3_97 VPWR VGND sg13g2_fill_1
XFILLER_37_756 VPWR VGND sg13g2_decap_8
XFILLER_3_1015 VPWR VGND sg13g2_decap_8
XFILLER_49_583 VPWR VGND sg13g2_decap_8
Xclkbuf_5_18__f_clk_regs _608_/CLK clkbuf_4_9_0_clk_regs/X VPWR VGND sg13g2_buf_16
XFILLER_28_756 VPWR VGND sg13g2_decap_8
X_220_ _220_/Y _472_/Q VPWR VGND sg13g2_inv_1
XFILLER_7_638 VPWR VGND sg13g2_decap_8
XFILLER_6_148 VPWR VGND sg13g2_fill_1
XFILLER_3_833 VPWR VGND sg13g2_decap_8
XFILLER_19_756 VPWR VGND sg13g2_fill_2
XFILLER_46_542 VPWR VGND sg13g2_decap_8
X_418_ _583_/D _609_/D _610_/D _435_/S VPWR VGND sg13g2_mux2_1
X_349_ _514_/D _513_/Q _514_/Q _410_/S VPWR VGND sg13g2_mux2_1
XFILLER_6_682 VPWR VGND sg13g2_decap_8
XFILLER_49_380 VPWR VGND sg13g2_decap_8
XFILLER_25_759 VPWR VGND sg13g2_decap_8
XFILLER_33_770 VPWR VGND sg13g2_decap_8
XFILLER_0_858 VPWR VGND sg13g2_decap_8
XFILLER_12_921 VPWR VGND sg13g2_decap_8
XFILLER_12_998 VPWR VGND sg13g2_decap_8
XFILLER_24_770 VPWR VGND sg13g2_decap_8
XFILLER_43_567 VPWR VGND sg13g2_decap_8
XFILLER_7_413 VPWR VGND sg13g2_decap_8
XFILLER_3_630 VPWR VGND sg13g2_decap_8
XFILLER_8_958 VPWR VGND sg13g2_decap_8
XFILLER_0_43 VPWR VGND sg13g2_fill_2
XFILLER_30_784 VPWR VGND sg13g2_fill_2
XFILLER_9_63 VPWR VGND sg13g2_fill_2
XFILLER_38_840 VPWR VGND sg13g2_decap_8
XFILLER_38_851 VPWR VGND sg13g2_fill_1
XFILLER_21_784 VPWR VGND sg13g2_decap_8
XFILLER_0_655 VPWR VGND sg13g2_decap_8
XFILLER_43_386 VPWR VGND sg13g2_decap_8
XFILLER_44_843 VPWR VGND sg13g2_decap_8
XFILLER_12_795 VPWR VGND sg13g2_decap_8
XFILLER_15_1015 VPWR VGND sg13g2_decap_8
XFILLER_47_681 VPWR VGND sg13g2_decap_8
XFILLER_45_618 VPWR VGND sg13g2_decap_8
Xclkbuf_regs_1_clk clkbuf_regs_1_clk/X _256_/Y VPWR VGND sg13g2_buf_16
XFILLER_5_758 VPWR VGND sg13g2_decap_8
XFILLER_4_279 VPWR VGND sg13g2_fill_1
XFILLER_4_202 VPWR VGND sg13g2_fill_2
XFILLER_0_452 VPWR VGND sg13g2_decap_8
XFILLER_1_975 VPWR VGND sg13g2_decap_8
XFILLER_48_467 VPWR VGND sg13g2_decap_8
XFILLER_44_640 VPWR VGND sg13g2_decap_8
X_597_ _626_/D _612_/CLK _597_/D fanout65/X VPWR VGND sg13g2_dfrbpq_1
XFILLER_13_0 VPWR VGND sg13g2_fill_1
XFILLER_45_415 VPWR VGND sg13g2_decap_8
X_520_ _520_/Q _657_/CLK _520_/D fanout81/X VPWR VGND sg13g2_dfrbpq_1
XFILLER_14_813 VPWR VGND sg13g2_decap_8
XFILLER_41_654 VPWR VGND sg13g2_decap_8
X_451_ _451_/Y _456_/A _455_/B VPWR VGND sg13g2_xnor2_1
X_382_ _547_/D _546_/Q _547_/Q _397_/S VPWR VGND sg13g2_mux2_1
XFILLER_1_772 VPWR VGND sg13g2_decap_8
XFILLER_5_599 VPWR VGND sg13g2_decap_8
X_649_ _649_/Q _657_/CLK _649_/D fanout89/X VPWR VGND sg13g2_dfrbpq_1
XFILLER_49_765 VPWR VGND sg13g2_decap_8
XFILLER_48_231 VPWR VGND sg13g2_decap_8
XFILLER_20_816 VPWR VGND sg13g2_decap_8
XFILLER_20_827 VPWR VGND sg13g2_fill_2
XFILLER_44_481 VPWR VGND sg13g2_decap_8
Xclkbuf_5_17__f_clk_regs _620_/CLK clkbuf_4_8_0_clk_regs/X VPWR VGND sg13g2_buf_16
XFILLER_9_861 VPWR VGND sg13g2_decap_8
Xu_custom_cells.u_mux0.mux_inst VGND VPWR _288_/B2 _570_/Q _574_/Q _571_/Q mux
XFILLER_11_838 VPWR VGND sg13g2_decap_8
XFILLER_2_569 VPWR VGND sg13g2_decap_8
XFILLER_45_278 VPWR VGND sg13g2_decap_8
X_503_ _503_/Q _506_/CLK _503_/D fanout85/X VPWR VGND sg13g2_dfrbpq_1
XFILLER_46_746 VPWR VGND sg13g2_decap_8
X_434_ _599_/D _598_/Q _599_/Q _435_/S VPWR VGND sg13g2_mux2_1
X_365_ _530_/D _529_/Q _530_/Q _369_/S VPWR VGND sg13g2_mux2_1
X_296_ _297_/B _295_/A _295_/B _311_/S VPWR VGND sg13g2_o21ai_1
XFILLER_10_893 VPWR VGND sg13g2_decap_8
XFILLER_6_875 VPWR VGND sg13g2_decap_8
XFILLER_49_562 VPWR VGND sg13g2_decap_8
XFILLER_16_919 VPWR VGND sg13g2_decap_8
XFILLER_42_215 VPWR VGND sg13g2_fill_1
XFILLER_43_749 VPWR VGND sg13g2_decap_8
XFILLER_3_812 VPWR VGND sg13g2_decap_8
XFILLER_7_617 VPWR VGND sg13g2_decap_8
XFILLER_6_127 VPWR VGND sg13g2_decap_8
XFILLER_3_889 VPWR VGND sg13g2_decap_8
XFILLER_34_749 VPWR VGND sg13g2_decap_8
XFILLER_46_598 VPWR VGND sg13g2_decap_4
XFILLER_46_521 VPWR VGND sg13g2_decap_8
XFILLER_41_270 VPWR VGND sg13g2_fill_1
XFILLER_42_782 VPWR VGND sg13g2_decap_8
X_417_ _582_/D _581_/Q _609_/D _436_/S VPWR VGND sg13g2_mux2_1
X_348_ _513_/D _512_/Q _513_/Q _348_/S VPWR VGND sg13g2_mux2_1
X_279_ _279_/Y _281_/A _279_/B VPWR VGND sg13g2_nor2_1
XFILLER_6_661 VPWR VGND sg13g2_decap_8
XFILLER_18_790 VPWR VGND sg13g2_decap_8
XFILLER_0_837 VPWR VGND sg13g2_decap_8
XFILLER_16_749 VPWR VGND sg13g2_fill_2
XFILLER_43_546 VPWR VGND sg13g2_decap_8
XFILLER_12_900 VPWR VGND sg13g2_decap_8
XFILLER_12_977 VPWR VGND sg13g2_decap_8
XFILLER_8_937 VPWR VGND sg13g2_decap_8
XFILLER_7_458 VPWR VGND sg13g2_decap_8
XFILLER_7_436 VPWR VGND sg13g2_fill_1
XFILLER_3_686 VPWR VGND sg13g2_decap_8
XFILLER_39_819 VPWR VGND sg13g2_decap_8
Xu_custom_cells.u_latmux.SwitchMatrixMultiplexer_inst _576_/Q VGND VPWR _288_/B2 _286_/B2
+ _282_/B2 _575_/Q SwitchMatrixMultiplexer
XFILLER_0_1019 VPWR VGND sg13g2_decap_8
XFILLER_46_395 VPWR VGND sg13g2_decap_8
XFILLER_30_763 VPWR VGND sg13g2_decap_8
XFILLER_43_0 VPWR VGND sg13g2_fill_2
XFILLER_21_763 VPWR VGND sg13g2_decap_8
XFILLER_0_634 VPWR VGND sg13g2_decap_8
XFILLER_48_649 VPWR VGND sg13g2_decap_8
XFILLER_44_822 VPWR VGND sg13g2_decap_8
XFILLER_12_774 VPWR VGND sg13g2_decap_8
XFILLER_7_244 VPWR VGND sg13g2_fill_2
XFILLER_7_233 VPWR VGND sg13g2_fill_1
XFILLER_4_995 VPWR VGND sg13g2_decap_8
XFILLER_47_660 VPWR VGND sg13g2_decap_8
XFILLER_26_844 VPWR VGND sg13g2_decap_8
XFILLER_41_836 VPWR VGND sg13g2_decap_8
XFILLER_5_737 VPWR VGND sg13g2_decap_8
XFILLER_5_704 VPWR VGND sg13g2_fill_1
XFILLER_1_954 VPWR VGND sg13g2_decap_8
XFILLER_17_833 VPWR VGND sg13g2_fill_2
XFILLER_49_947 VPWR VGND sg13g2_fill_2
XFILLER_48_446 VPWR VGND sg13g2_decap_8
XFILLER_44_696 VPWR VGND sg13g2_decap_8
X_596_ _596_/Q _624_/CLK _596_/D fanout68/X VPWR VGND sg13g2_dfrbpq_1
Xclkbuf_5_16__f_clk_regs _621_/CLK clkbuf_4_8_0_clk_regs/X VPWR VGND sg13g2_buf_16
XFILLER_6_98 VPWR VGND sg13g2_decap_8
XFILLER_4_792 VPWR VGND sg13g2_decap_8
XFILLER_9_9 VPWR VGND sg13g2_fill_1
XFILLER_14_869 VPWR VGND sg13g2_decap_8
XFILLER_41_633 VPWR VGND sg13g2_decap_8
X_450_ _450_/Y _456_/A _455_/B VPWR VGND sg13g2_xnor2_1
X_381_ _546_/D _545_/Q _546_/Q _397_/S VPWR VGND sg13g2_mux2_1
XFILLER_12_1019 VPWR VGND sg13g2_decap_8
XFILLER_5_578 VPWR VGND sg13g2_decap_8
XFILLER_1_751 VPWR VGND sg13g2_decap_8
XFILLER_49_744 VPWR VGND sg13g2_decap_8
XFILLER_44_460 VPWR VGND sg13g2_decap_8
X_648_ _648_/Q _648_/CLK _648_/D fanout78/X VPWR VGND sg13g2_dfrbpq_1
XFILLER_20_839 VPWR VGND sg13g2_decap_8
X_579_ _579_/Q _622_/CLK _579_/D fanout84/X VPWR VGND sg13g2_dfrbpq_1
XFILLER_9_840 VPWR VGND sg13g2_decap_8
XFILLER_11_817 VPWR VGND sg13g2_decap_8
XFILLER_2_548 VPWR VGND sg13g2_decap_8
Xdelaybuf_0_clk u_delay_line/clk _444_/B VPWR VGND sg13g2_buf_16
XFILLER_45_257 VPWR VGND sg13g2_decap_8
X_502_ _502_/Q _506_/CLK _502_/D fanout85/X VPWR VGND sg13g2_dfrbpq_1
X_433_ _598_/D _626_/D _598_/Q _435_/S VPWR VGND sg13g2_mux2_1
XFILLER_46_725 VPWR VGND sg13g2_decap_8
XFILLER_10_872 VPWR VGND sg13g2_decap_8
X_364_ _529_/D _528_/Q _529_/Q _369_/S VPWR VGND sg13g2_mux2_1
X_295_ _295_/Y _295_/A _295_/B VPWR VGND sg13g2_nor2_1
XFILLER_6_854 VPWR VGND sg13g2_decap_8
XFILLER_5_342 VPWR VGND sg13g2_decap_8
XFILLER_49_541 VPWR VGND sg13g2_decap_8
XFILLER_36_791 VPWR VGND sg13g2_decap_8
XFILLER_43_728 VPWR VGND sg13g2_decap_8
XFILLER_3_868 VPWR VGND sg13g2_decap_8
XFILLER_2_367 VPWR VGND sg13g2_fill_1
XFILLER_46_500 VPWR VGND sg13g2_decap_8
XFILLER_27_791 VPWR VGND sg13g2_decap_8
XFILLER_42_761 VPWR VGND sg13g2_decap_8
X_416_ _581_/D _607_/D _581_/Q _429_/S VPWR VGND sg13g2_mux2_1
XFILLER_46_577 VPWR VGND sg13g2_decap_8
X_347_ _512_/D _511_/Q _512_/Q _410_/S VPWR VGND sg13g2_mux2_1
X_278_ _634_/D _612_/Q _626_/Q _278_/S VPWR VGND sg13g2_mux2_1
XFILLER_6_640 VPWR VGND sg13g2_decap_8
XFILLER_0_816 VPWR VGND sg13g2_decap_8
XFILLER_12_956 VPWR VGND sg13g2_decap_8
XFILLER_8_916 VPWR VGND sg13g2_decap_8
XFILLER_2_120 VPWR VGND sg13g2_fill_1
XFILLER_3_0 VPWR VGND sg13g2_fill_2
XFILLER_3_665 VPWR VGND sg13g2_decap_8
XFILLER_0_45 VPWR VGND sg13g2_fill_1
XFILLER_46_374 VPWR VGND sg13g2_decap_8
XFILLER_47_842 VPWR VGND sg13g2_decap_8
XFILLER_15_783 VPWR VGND sg13g2_decap_8
XFILLER_30_786 VPWR VGND sg13g2_fill_1
XFILLER_9_1001 VPWR VGND sg13g2_fill_2
XFILLER_5_919 VPWR VGND sg13g2_decap_8
XFILLER_0_613 VPWR VGND sg13g2_decap_8
XFILLER_44_801 VPWR VGND sg13g2_decap_8
XFILLER_48_628 VPWR VGND sg13g2_decap_8
XFILLER_43_333 VPWR VGND sg13g2_decap_8
Xclkbuf_5_15__f_clk_regs _535_/CLK clkbuf_4_7_0_clk_regs/X VPWR VGND sg13g2_buf_16
XFILLER_3_451 VPWR VGND sg13g2_fill_1
XFILLER_3_462 VPWR VGND sg13g2_decap_4
XFILLER_4_974 VPWR VGND sg13g2_decap_8
XFILLER_35_812 VPWR VGND sg13g2_decap_8
XFILLER_35_823 VPWR VGND sg13g2_fill_1
XFILLER_26_823 VPWR VGND sg13g2_decap_8
XFILLER_41_815 VPWR VGND sg13g2_decap_8
XFILLER_4_204 VPWR VGND sg13g2_fill_1
XFILLER_1_933 VPWR VGND sg13g2_decap_8
XFILLER_49_926 VPWR VGND sg13g2_decap_8
XFILLER_48_425 VPWR VGND sg13g2_decap_8
XFILLER_17_812 VPWR VGND sg13g2_decap_8
XFILLER_44_675 VPWR VGND sg13g2_decap_8
X_595_ _624_/D _609_/CLK _595_/D fanout65/X VPWR VGND sg13g2_dfrbpq_1
XFILLER_4_771 VPWR VGND sg13g2_decap_8
XFILLER_6_1015 VPWR VGND sg13g2_decap_8
XFILLER_23_837 VPWR VGND sg13g2_decap_8
Xclkbuf_4_12_0_clk_regs clkbuf_4_12_0_clk_regs/X clkbuf_0_clk_regs/X VPWR VGND sg13g2_buf_8
XFILLER_14_848 VPWR VGND sg13g2_decap_8
XFILLER_41_612 VPWR VGND sg13g2_decap_8
XFILLER_41_689 VPWR VGND sg13g2_decap_8
X_380_ _545_/D _544_/Q _545_/Q _391_/S VPWR VGND sg13g2_mux2_1
Xoutput30 uo_out[0] _280_/X VPWR VGND sg13g2_buf_1
XFILLER_5_557 VPWR VGND sg13g2_decap_8
XFILLER_1_730 VPWR VGND sg13g2_decap_8
XFILLER_49_723 VPWR VGND sg13g2_decap_8
X_578_ _578_/Q _578_/CLK _578_/D fanout88/X VPWR VGND sg13g2_dfrbpq_1
X_647_ _647_/Q _647_/CLK _647_/D fanout77/X VPWR VGND sg13g2_dfrbpq_1
XFILLER_48_299 VPWR VGND sg13g2_decap_8
XFILLER_9_896 VPWR VGND sg13g2_decap_8
.ends
