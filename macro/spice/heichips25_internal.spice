* NGSPICE file created from heichips25_internal.ext - technology: ihp-sg13g2

* Black-box entry subcircuit for sg13g2_decap_8 abstract view
.subckt sg13g2_decap_8 VDD VSS
.ends

* Black-box entry subcircuit for sg13g2_dfrbpq_1 abstract view
.subckt sg13g2_dfrbpq_1 Q CLK D RESET_B VDD VSS
.ends

* Black-box entry subcircuit for sg13g2_mux2_1 abstract view
.subckt sg13g2_mux2_1 X A0 A1 S VDD VSS
.ends

* Black-box entry subcircuit for sg13g2_nand4_1 abstract view
.subckt sg13g2_nand4_1 Y A B C D VDD VSS
.ends

* Black-box entry subcircuit for sg13g2_buf_16 abstract view
.subckt sg13g2_buf_16 X A VDD VSS
.ends

* Black-box entry subcircuit for sg13g2_fill_1 abstract view
.subckt sg13g2_fill_1 VDD VSS
.ends

* Black-box entry subcircuit for sg13g2_decap_4 abstract view
.subckt sg13g2_decap_4 VDD VSS
.ends

* Black-box entry subcircuit for sg13g2_antennanp abstract view
.subckt sg13g2_antennanp A VDD VSS
.ends

* Black-box entry subcircuit for sg13g2_buf_1 abstract view
.subckt sg13g2_buf_1 X A VDD VSS
.ends

* Black-box entry subcircuit for sg13g2_nand3b_1 abstract view
.subckt sg13g2_nand3b_1 Y A_N B C VDD VSS
.ends

* Black-box entry subcircuit for sg13g2_and2_1 abstract view
.subckt sg13g2_and2_1 X A B VDD VSS
.ends

* Black-box entry subcircuit for sg13g2_fill_2 abstract view
.subckt sg13g2_fill_2 VDD VSS
.ends

* Black-box entry subcircuit for sg13g2_nor2_1 abstract view
.subckt sg13g2_nor2_1 Y A B VDD VSS
.ends

* Black-box entry subcircuit for sg13g2_buf_8 abstract view
.subckt sg13g2_buf_8 X A VDD VSS
.ends

* Black-box entry subcircuit for sg13g2_nand2b_1 abstract view
.subckt sg13g2_nand2b_1 Y A_N B VDD VSS
.ends

* Black-box entry subcircuit for sg13g2_dlygate4sd3_1 abstract view
.subckt sg13g2_dlygate4sd3_1 X A VDD VSS
.ends

* Black-box entry subcircuit for sg13g2_a21oi_1 abstract view
.subckt sg13g2_a21oi_1 Y A1 A2 B1 VDD VSS
.ends

* Black-box entry subcircuit for sg13g2_nor2b_1 abstract view
.subckt sg13g2_nor2b_1 Y A B_N VDD VSS
.ends

* Black-box entry subcircuit for sg13g2_xnor2_1 abstract view
.subckt sg13g2_xnor2_1 Y A B VDD VSS
.ends

* Black-box entry subcircuit for delay_line abstract view
.subckt delay_line VDD VSS clk clk_delayed reset sel[0] sel[1] sel[2] sel[3] trim[0]
+ trim[10] trim[11] trim[12] trim[13] trim[14] trim[15] trim[16] trim[17] trim[18]
+ trim[19] trim[1] trim[20] trim[21] trim[22] trim[23] trim[2] trim[3] trim[4] trim[5]
+ trim[6] trim[7] trim[8] trim[9]
.ends

* Black-box entry subcircuit for sg13g2_inv_4 abstract view
.subckt sg13g2_inv_4 Y A VDD VSS
.ends

* Black-box entry subcircuit for sg13g2_nand2_1 abstract view
.subckt sg13g2_nand2_1 Y A B VDD VSS
.ends

* Black-box entry subcircuit for sg13g2_inv_1 abstract view
.subckt sg13g2_inv_1 Y A VDD VSS
.ends

* Black-box entry subcircuit for sg13g2_xor2_1 abstract view
.subckt sg13g2_xor2_1 X A B VDD VSS
.ends

* Black-box entry subcircuit for sg13g2_nor3_1 abstract view
.subckt sg13g2_nor3_1 Y A B C VDD VSS
.ends

* Black-box entry subcircuit for sg13g2_nand3_1 abstract view
.subckt sg13g2_nand3_1 Y A B C VDD VSS
.ends

* Black-box entry subcircuit for sg13g2_o21ai_1 abstract view
.subckt sg13g2_o21ai_1 Y A1 A2 B1 VDD VSS
.ends

* Black-box entry subcircuit for sg13g2_a22oi_1 abstract view
.subckt sg13g2_a22oi_1 Y A1 A2 B1 B2 VDD VSS
.ends

* Black-box entry subcircuit for sg13g2_inv_2 abstract view
.subckt sg13g2_inv_2 Y A VDD VSS
.ends

* Black-box entry subcircuit for sg13g2_or2_1 abstract view
.subckt sg13g2_or2_1 X A B VDD VSS
.ends

* Black-box entry subcircuit for sg13g2_mux4_1 abstract view
.subckt sg13g2_mux4_1 X A0 A1 A2 A3 S0 S1 VDD VSS
.ends

* Black-box entry subcircuit for multimode_dll abstract view
.subckt multimode_dll VDD VSS bias clk0_out clk0_phase_sel[0] clk0_phase_sel[1] clk0_phase_sel[2]
+ clk0_phase_sel[3] clk0_phase_sel[4] clk1_out clk1_phase_sel[0] clk1_phase_sel[1]
+ clk1_phase_sel[2] clk1_phase_sel[3] clk1_phase_sel[4] clk2_out clk2_phase_sel[0]
+ clk2_phase_sel[1] clk2_phase_sel[2] clk2_phase_sel[3] clk2_phase_sel[4] dco enable
+ ext_trim[0] ext_trim[10] ext_trim[11] ext_trim[12] ext_trim[13] ext_trim[14] ext_trim[15]
+ ext_trim[16] ext_trim[17] ext_trim[18] ext_trim[19] ext_trim[1] ext_trim[20] ext_trim[21]
+ ext_trim[22] ext_trim[23] ext_trim[24] ext_trim[25] ext_trim[2] ext_trim[3] ext_trim[4]
+ ext_trim[5] ext_trim[6] ext_trim[7] ext_trim[8] ext_trim[9] f_clk0_divider[0] f_clk0_divider[1]
+ f_clk0_divider[2] f_clk0_divider[3] f_clk0_divider[4] f_clk1_divider[0] f_clk1_divider[1]
+ f_clk1_divider[2] f_clk1_divider[3] f_clk1_divider[4] f_clk2_divider[0] f_clk2_divider[1]
+ f_clk2_divider[2] f_clk2_divider[3] f_clk2_divider[4] f_osc_multiply_factor[0] f_osc_multiply_factor[1]
+ f_osc_multiply_factor[2] f_osc_multiply_factor[3] f_osc_multiply_factor[4] mode_xor[0]
+ mode_xor[1] mode_xor[2] osc osc_out resetb stable
.ends

* Black-box entry subcircuit for SwitchMatrixMultiplexer_inv abstract view
.subckt SwitchMatrixMultiplexer_inv D A VDD B X VSS SEL
.ends

* Black-box entry subcircuit for mux_inv abstract view
.subckt mux_inv X VDD VSS SEL B A
.ends

* Black-box entry subcircuit for latch abstract view
.subckt latch Q D VSS VDD GATE
.ends

* Black-box entry subcircuit for sg13g2_a21o_1 abstract view
.subckt sg13g2_a21o_1 X A1 A2 B1 VDD VSS
.ends

* Black-box entry subcircuit for mux abstract view
.subckt mux VSS VDD X A SEL B
.ends

* Black-box entry subcircuit for SwitchMatrixMultiplexer abstract view
.subckt SwitchMatrixMultiplexer D VSS VDD A B X SEL
.ends

.subckt heichips25_internal VGND VPWR analog_pin0 analog_pin1 analog_pin2 clk ena
+ rst_n ui_in[0] ui_in[1] ui_in[2] ui_in[3] ui_in[4] ui_in[5] ui_in[6] ui_in[7] uio_in[0]
+ uio_in[1] uio_in[2] uio_in[3] uio_in[4] uio_in[5] uio_in[6] uio_in[7] uio_oe[0]
+ uio_oe[1] uio_oe[2] uio_oe[3] uio_oe[4] uio_oe[5] uio_oe[6] uio_oe[7] uio_out[0]
+ uio_out[1] uio_out[2] uio_out[3] uio_out[4] uio_out[5] uio_out[6] uio_out[7] uo_out[0]
+ uo_out[1] uo_out[2] uo_out[3] uo_out[4] uo_out[5] uo_out[6] uo_out[7]
XFILLER_2_505 VPWR VGND sg13g2_decap_8
XFILLER_46_726 VPWR VGND sg13g2_decap_8
X_501_ _501_/Q _621_/CLK _501_/D fanout87/X VPWR VGND sg13g2_dfrbpq_1
X_432_ _597_/D _596_/Q _626_/D _432_/S VPWR VGND sg13g2_mux2_1
XFILLER_10_840 VPWR VGND sg13g2_decap_8
X_363_ _528_/D _527_/Q _528_/Q _374_/S VPWR VGND sg13g2_mux2_1
X_294_ _295_/B _469_/Q _471_/Q _472_/Q _475_/Q VPWR VGND sg13g2_nand4_1
XFILLER_6_800 VPWR VGND sg13g2_decap_8
XFILLER_6_877 VPWR VGND sg13g2_decap_8
XFILLER_5_387 VPWR VGND sg13g2_decap_8
XFILLER_3_1018 VPWR VGND sg13g2_decap_8
XFILLER_49_531 VPWR VGND sg13g2_decap_8
XFILLER_45_792 VPWR VGND sg13g2_decap_8
XFILLER_36_770 VPWR VGND sg13g2_decap_8
XFILLER_43_707 VPWR VGND sg13g2_decap_8
XFILLER_3_836 VPWR VGND sg13g2_decap_8
XFILLER_27_770 VPWR VGND sg13g2_decap_8
XFILLER_42_740 VPWR VGND sg13g2_decap_8
X_415_ _580_/D _579_/Q _580_/Q _415_/S VPWR VGND sg13g2_mux2_1
X_346_ _511_/D _510_/Q _511_/Q _416_/S VPWR VGND sg13g2_mux2_1
X_277_ _633_/D _277_/A0 _625_/Q _278_/S VPWR VGND sg13g2_mux2_1
XFILLER_6_663 VPWR VGND sg13g2_decap_8
XFILLER_18_770 VPWR VGND sg13g2_decap_8
XFILLER_33_784 VPWR VGND sg13g2_decap_8
XFILLER_0_806 VPWR VGND sg13g2_decap_8
XFILLER_12_902 VPWR VGND sg13g2_decap_8
XFILLER_24_784 VPWR VGND sg13g2_decap_8
Xclkbuf_5_14__f_clk_regs _570_/CLK clkbuf_4_7_0_clk_regs/X VPWR VGND sg13g2_buf_16
XFILLER_12_979 VPWR VGND sg13g2_decap_8
XFILLER_3_633 VPWR VGND sg13g2_decap_8
XFILLER_46_364 VPWR VGND sg13g2_decap_8
XFILLER_15_784 VPWR VGND sg13g2_decap_8
XFILLER_30_798 VPWR VGND sg13g2_decap_8
XFILLER_42_581 VPWR VGND sg13g2_decap_8
X_329_ _494_/D _493_/Q _494_/Q _392_/S VPWR VGND sg13g2_mux2_1
XFILLER_7_961 VPWR VGND sg13g2_decap_8
XFILLER_21_798 VPWR VGND sg13g2_decap_8
XFILLER_0_603 VPWR VGND sg13g2_decap_8
XFILLER_34_63 VPWR VGND sg13g2_fill_1
XFILLER_43_378 VPWR VGND sg13g2_decap_8
XFILLER_8_769 VPWR VGND sg13g2_decap_8
XFILLER_7_246 VPWR VGND sg13g2_decap_4
XFILLER_4_942 VPWR VGND sg13g2_decap_8
XFILLER_41_827 VPWR VGND sg13g2_decap_8
XFILLER_0_477 VPWR VGND sg13g2_decap_8
XFILLER_1_934 VPWR VGND sg13g2_decap_8
XFILLER_49_927 VPWR VGND sg13g2_decap_8
XFILLER_48_437 VPWR VGND sg13g2_decap_8
XFILLER_44_632 VPWR VGND sg13g2_decap_8
X_594_ _594_/Q _616_/CLK _594_/D fanout73/X VPWR VGND sg13g2_dfrbpq_1
XANTENNA_5 _283_/Y VPWR VGND sg13g2_antennanp
XFILLER_23_838 VPWR VGND sg13g2_decap_8
Xdelaybuf_10_clk delaybuf_11_clk/A clkload0/A VPWR VGND sg13g2_buf_16
XFILLER_14_805 VPWR VGND sg13g2_decap_8
XFILLER_41_613 VPWR VGND sg13g2_decap_8
XFILLER_1_731 VPWR VGND sg13g2_decap_8
Xoutput31 uo_out[1] _283_/Y VPWR VGND sg13g2_buf_1
Xoutput20 uio_oe[6] _255_/X VPWR VGND sg13g2_buf_1
XFILLER_5_547 VPWR VGND sg13g2_decap_8
XFILLER_0_285 VPWR VGND sg13g2_fill_1
XFILLER_0_296 VPWR VGND sg13g2_decap_8
Xclkbuf_2_0__f_clk_delayed _460_/A clkbuf_0_clk_delayed/X VPWR VGND sg13g2_buf_16
XFILLER_49_724 VPWR VGND sg13g2_decap_8
XFILLER_13_860 VPWR VGND sg13g2_decap_8
XFILLER_20_819 VPWR VGND sg13g2_decap_8
XFILLER_44_440 VPWR VGND sg13g2_fill_1
X_577_ _577_/Q _577_/CLK _577_/D fanout82/X VPWR VGND sg13g2_dfrbpq_1
X_646_ _646_/Q _460_/Y _647_/D fanout77/X VPWR VGND sg13g2_dfrbpq_1
XFILLER_9_886 VPWR VGND sg13g2_decap_8
XFILLER_11_819 VPWR VGND sg13g2_decap_8
X_500_ _500_/Q _513_/CLK _500_/D fanout88/X VPWR VGND sg13g2_dfrbpq_1
XFILLER_46_705 VPWR VGND sg13g2_decap_8
X_431_ _596_/D _624_/D _596_/Q _432_/S VPWR VGND sg13g2_mux2_1
X_362_ _527_/D _526_/Q _527_/Q _374_/S VPWR VGND sg13g2_mux2_1
XFILLER_10_896 VPWR VGND sg13g2_decap_8
X_293_ _295_/A _470_/Q _473_/Q _474_/Q VPWR VGND sg13g2_nand3b_1
XFILLER_6_856 VPWR VGND sg13g2_decap_8
XFILLER_49_510 VPWR VGND sg13g2_decap_8
XFILLER_37_749 VPWR VGND sg13g2_decap_8
XFILLER_45_771 VPWR VGND sg13g2_decap_8
X_629_ _629_/Q _630_/CLK _629_/D fanout66/X VPWR VGND sg13g2_dfrbpq_1
XFILLER_49_598 VPWR VGND sg13g2_fill_1
XFILLER_49_587 VPWR VGND sg13g2_decap_8
XFILLER_28_749 VPWR VGND sg13g2_decap_8
Xclkbuf_5_13__f_clk_regs _567_/CLK clkbuf_4_6_0_clk_regs/X VPWR VGND sg13g2_buf_16
XFILLER_3_815 VPWR VGND sg13g2_decap_8
XFILLER_19_749 VPWR VGND sg13g2_decap_8
XFILLER_46_579 VPWR VGND sg13g2_decap_8
XFILLER_15_977 VPWR VGND sg13g2_fill_1
X_414_ _579_/D _578_/Q _579_/Q _428_/S VPWR VGND sg13g2_mux2_1
X_345_ _510_/D _509_/Q _510_/Q _415_/S VPWR VGND sg13g2_mux2_1
X_276_ _632_/D _276_/A0 _624_/Q _278_/S VPWR VGND sg13g2_mux2_1
XFILLER_6_642 VPWR VGND sg13g2_decap_8
XFILLER_49_384 VPWR VGND sg13g2_decap_8
XFILLER_33_763 VPWR VGND sg13g2_decap_8
XFILLER_12_958 VPWR VGND sg13g2_decap_8
XFILLER_24_763 VPWR VGND sg13g2_decap_8
XFILLER_3_612 VPWR VGND sg13g2_decap_8
XFILLER_3_689 VPWR VGND sg13g2_decap_8
XFILLER_15_763 VPWR VGND sg13g2_decap_8
XFILLER_46_343 VPWR VGND sg13g2_decap_8
XFILLER_47_844 VPWR VGND sg13g2_decap_8
XFILLER_11_980 VPWR VGND sg13g2_decap_8
XFILLER_30_777 VPWR VGND sg13g2_decap_8
XFILLER_42_560 VPWR VGND sg13g2_decap_8
X_328_ _493_/D _492_/Q _493_/Q _331_/S VPWR VGND sg13g2_mux2_1
X_259_ _259_/X _643_/Q _259_/B VPWR VGND sg13g2_and2_1
XFILLER_7_940 VPWR VGND sg13g2_decap_8
XFILLER_38_833 VPWR VGND sg13g2_decap_8
XFILLER_21_777 VPWR VGND sg13g2_decap_8
XFILLER_0_659 VPWR VGND sg13g2_decap_8
XFILLER_48_619 VPWR VGND sg13g2_decap_8
XFILLER_43_335 VPWR VGND sg13g2_fill_1
XFILLER_44_836 VPWR VGND sg13g2_decap_8
XFILLER_15_1019 VPWR VGND sg13g2_decap_8
XFILLER_3_486 VPWR VGND sg13g2_decap_8
XFILLER_4_998 VPWR VGND sg13g2_decap_8
XFILLER_4_921 VPWR VGND sg13g2_decap_8
XFILLER_47_641 VPWR VGND sg13g2_decap_8
XFILLER_41_0 VPWR VGND sg13g2_fill_2
XFILLER_26_847 VPWR VGND sg13g2_decap_4
XFILLER_41_806 VPWR VGND sg13g2_decap_8
XFILLER_1_913 VPWR VGND sg13g2_decap_8
XFILLER_5_729 VPWR VGND sg13g2_decap_8
XFILLER_0_456 VPWR VGND sg13g2_decap_8
XFILLER_49_906 VPWR VGND sg13g2_decap_8
XFILLER_48_416 VPWR VGND sg13g2_decap_8
XFILLER_44_611 VPWR VGND sg13g2_decap_8
XFILLER_44_688 VPWR VGND sg13g2_decap_8
XFILLER_45_85 VPWR VGND sg13g2_fill_1
X_593_ _593_/Q _593_/CLK _593_/D fanout74/X VPWR VGND sg13g2_dfrbpq_1
XFILLER_6_1028 VPWR VGND sg13g2_fill_1
XFILLER_6_1017 VPWR VGND sg13g2_decap_8
XFILLER_4_795 VPWR VGND sg13g2_decap_8
XFILLER_47_493 VPWR VGND sg13g2_decap_8
XFILLER_23_817 VPWR VGND sg13g2_decap_8
XFILLER_5_526 VPWR VGND sg13g2_decap_8
XFILLER_0_253 VPWR VGND sg13g2_fill_2
XFILLER_1_710 VPWR VGND sg13g2_decap_8
XFILLER_1_787 VPWR VGND sg13g2_decap_8
Xdelaybuf_3_clk delaybuf_4_clk/A delaybuf_3_clk/A VPWR VGND sg13g2_buf_16
Xoutput32 uo_out[2] _285_/Y VPWR VGND sg13g2_buf_1
Xoutput21 uio_oe[7] _258_/Y VPWR VGND sg13g2_buf_1
XFILLER_49_703 VPWR VGND sg13g2_decap_8
X_645_ _645_/Q _459_/Y _645_/D fanout76/X VPWR VGND sg13g2_dfrbpq_1
XFILLER_48_279 VPWR VGND sg13g2_fill_2
X_576_ _576_/Q _657_/CLK _576_/D fanout82/X VPWR VGND sg13g2_dfrbpq_1
XFILLER_9_865 VPWR VGND sg13g2_decap_8
Xclkbuf_5_12__f_clk_regs _569_/CLK clkbuf_4_6_0_clk_regs/X VPWR VGND sg13g2_buf_16
XFILLER_4_592 VPWR VGND sg13g2_decap_8
XFILLER_47_290 VPWR VGND sg13g2_decap_8
XFILLER_11_1022 VPWR VGND sg13g2_decap_8
XFILLER_39_791 VPWR VGND sg13g2_decap_8
X_430_ _595_/D _594_/Q _624_/D _432_/S VPWR VGND sg13g2_mux2_1
X_361_ _526_/D _525_/Q _526_/Q _374_/S VPWR VGND sg13g2_mux2_1
X_292_ _307_/A _473_/Q _474_/Q VPWR VGND sg13g2_and2_1
XFILLER_10_875 VPWR VGND sg13g2_decap_8
XFILLER_6_835 VPWR VGND sg13g2_decap_8
XFILLER_1_584 VPWR VGND sg13g2_decap_8
XFILLER_49_566 VPWR VGND sg13g2_decap_8
XFILLER_45_750 VPWR VGND sg13g2_decap_8
X_628_ _628_/Q _628_/CLK _628_/D fanout66/X VPWR VGND sg13g2_dfrbpq_1
XFILLER_44_293 VPWR VGND sg13g2_decap_8
X_559_ _559_/Q _561_/CLK _559_/D fanout94/X VPWR VGND sg13g2_dfrbpq_1
XFILLER_5_890 VPWR VGND sg13g2_decap_8
XFILLER_2_359 VPWR VGND sg13g2_decap_8
XFILLER_15_934 VPWR VGND sg13g2_fill_2
X_413_ _578_/D _577_/Q _578_/Q _428_/S VPWR VGND sg13g2_mux2_1
XFILLER_46_558 VPWR VGND sg13g2_decap_8
XFILLER_46_503 VPWR VGND sg13g2_decap_8
XFILLER_42_775 VPWR VGND sg13g2_decap_8
X_344_ _509_/D _508_/Q _509_/Q _429_/S VPWR VGND sg13g2_mux2_1
X_275_ _275_/X _275_/A0 _623_/Q _278_/S VPWR VGND sg13g2_mux2_1
XFILLER_6_621 VPWR VGND sg13g2_decap_8
XFILLER_6_698 VPWR VGND sg13g2_decap_4
XFILLER_1_392 VPWR VGND sg13g2_decap_4
XFILLER_49_363 VPWR VGND sg13g2_decap_8
XFILLER_12_937 VPWR VGND sg13g2_decap_8
XFILLER_7_429 VPWR VGND sg13g2_decap_8
XFILLER_2_101 VPWR VGND sg13g2_fill_2
XFILLER_3_668 VPWR VGND sg13g2_decap_8
XFILLER_46_322 VPWR VGND sg13g2_decap_8
XFILLER_47_823 VPWR VGND sg13g2_decap_8
XFILLER_0_48 VPWR VGND sg13g2_fill_1
XFILLER_47_889 VPWR VGND sg13g2_decap_8
XFILLER_46_399 VPWR VGND sg13g2_decap_8
XFILLER_30_756 VPWR VGND sg13g2_decap_8
X_327_ _492_/D _491_/Q _492_/Q _331_/S VPWR VGND sg13g2_mux2_1
X_258_ _258_/Y _258_/A _258_/B VPWR VGND sg13g2_nor2_1
XFILLER_9_1026 VPWR VGND sg13g2_fill_2
XFILLER_7_996 VPWR VGND sg13g2_decap_8
XFILLER_6_495 VPWR VGND sg13g2_decap_8
XFILLER_38_812 VPWR VGND sg13g2_decap_8
Xclkbuf_4_9_0_clk_regs clkbuf_4_9_0_clk_regs/X clkbuf_0_clk_regs/X VPWR VGND sg13g2_buf_8
XFILLER_21_756 VPWR VGND sg13g2_decap_8
XFILLER_0_638 VPWR VGND sg13g2_decap_8
XFILLER_29_812 VPWR VGND sg13g2_decap_8
XFILLER_29_823 VPWR VGND sg13g2_fill_2
XFILLER_44_815 VPWR VGND sg13g2_decap_8
XFILLER_4_900 VPWR VGND sg13g2_decap_8
XFILLER_3_443 VPWR VGND sg13g2_decap_8
XFILLER_4_977 VPWR VGND sg13g2_decap_8
XFILLER_35_848 VPWR VGND sg13g2_decap_4
XFILLER_47_697 VPWR VGND sg13g2_decap_8
XFILLER_47_620 VPWR VGND sg13g2_decap_8
XFILLER_7_793 VPWR VGND sg13g2_decap_8
XFILLER_26_826 VPWR VGND sg13g2_decap_8
XFILLER_5_708 VPWR VGND sg13g2_decap_8
XFILLER_0_435 VPWR VGND sg13g2_decap_8
XFILLER_1_969 VPWR VGND sg13g2_decap_8
XFILLER_17_826 VPWR VGND sg13g2_decap_8
XFILLER_17_837 VPWR VGND sg13g2_fill_1
X_592_ _592_/Q _620_/CLK _592_/D fanout85/X VPWR VGND sg13g2_dfrbpq_1
XFILLER_40_840 VPWR VGND sg13g2_decap_8
XFILLER_40_851 VPWR VGND sg13g2_fill_1
XFILLER_44_667 VPWR VGND sg13g2_decap_8
Xclkbuf_5_11__f_clk_regs _534_/CLK clkbuf_4_5_0_clk_regs/X VPWR VGND sg13g2_buf_16
XFILLER_4_774 VPWR VGND sg13g2_decap_8
XFILLER_47_472 VPWR VGND sg13g2_decap_8
XFILLER_31_851 VPWR VGND sg13g2_fill_1
XFILLER_7_590 VPWR VGND sg13g2_decap_8
XFILLER_45_409 VPWR VGND sg13g2_decap_8
XFILLER_41_659 VPWR VGND sg13g2_decap_4
XFILLER_1_766 VPWR VGND sg13g2_decap_8
Xoutput33 uo_out[3] _287_/Y VPWR VGND sg13g2_buf_1
Xoutput22 uio_out[0] _242_/X VPWR VGND sg13g2_buf_1
XFILLER_49_759 VPWR VGND sg13g2_decap_8
X_575_ _575_/Q _659_/CLK _575_/D fanout82/X VPWR VGND sg13g2_dfrbpq_1
X_644_ _644_/Q _458_/Y _644_/D fanout77/X VPWR VGND sg13g2_dfrbpq_1
XFILLER_13_895 VPWR VGND sg13g2_decap_8
XFILLER_9_844 VPWR VGND sg13g2_decap_8
XFILLER_4_571 VPWR VGND sg13g2_decap_8
XFILLER_11_1001 VPWR VGND sg13g2_decap_8
XFILLER_2_519 VPWR VGND sg13g2_decap_8
XFILLER_39_770 VPWR VGND sg13g2_decap_8
XFILLER_10_854 VPWR VGND sg13g2_decap_8
X_360_ _525_/D _524_/Q _525_/Q _374_/S VPWR VGND sg13g2_mux2_1
X_291_ _291_/Y _602_/Q _291_/B VPWR VGND sg13g2_nand2b_1
Xclkbuf_4_11_0_clk_regs clkbuf_4_11_0_clk_regs/X clkbuf_0_clk_regs/X VPWR VGND sg13g2_buf_8
XFILLER_6_814 VPWR VGND sg13g2_decap_8
XFILLER_5_335 VPWR VGND sg13g2_decap_8
XFILLER_5_324 VPWR VGND sg13g2_fill_1
XFILLER_1_563 VPWR VGND sg13g2_decap_8
XFILLER_49_545 VPWR VGND sg13g2_decap_8
X_558_ _558_/Q _562_/CLK _558_/D fanout94/X VPWR VGND sg13g2_dfrbpq_1
X_627_ _627_/Q _630_/CLK _627_/D fanout65/X VPWR VGND sg13g2_dfrbpq_1
X_489_ _489_/Q _511_/CLK _489_/D fanout87/X VPWR VGND sg13g2_dfrbpq_1
XFILLER_36_784 VPWR VGND sg13g2_decap_8
Xhold140 _628_/D _599_/Q VPWR VGND sg13g2_dlygate4sd3_1
XFILLER_27_784 VPWR VGND sg13g2_decap_8
XFILLER_42_754 VPWR VGND sg13g2_decap_8
X_412_ _577_/D _576_/Q _577_/Q _412_/S VPWR VGND sg13g2_mux2_1
X_343_ _508_/D _507_/Q _508_/Q _429_/S VPWR VGND sg13g2_mux2_1
X_274_ _274_/X _274_/A0 _630_/Q _278_/S VPWR VGND sg13g2_mux2_1
XFILLER_6_600 VPWR VGND sg13g2_decap_8
XFILLER_2_883 VPWR VGND sg13g2_decap_8
XFILLER_6_677 VPWR VGND sg13g2_decap_8
XFILLER_5_187 VPWR VGND sg13g2_fill_1
XFILLER_49_342 VPWR VGND sg13g2_decap_8
XFILLER_18_784 VPWR VGND sg13g2_decap_8
XFILLER_33_798 VPWR VGND sg13g2_decap_4
XFILLER_12_916 VPWR VGND sg13g2_decap_8
XFILLER_24_798 VPWR VGND sg13g2_decap_8
XFILLER_8_909 VPWR VGND sg13g2_decap_8
XFILLER_2_124 VPWR VGND sg13g2_fill_1
XFILLER_3_647 VPWR VGND sg13g2_decap_8
XFILLER_46_301 VPWR VGND sg13g2_decap_8
XFILLER_47_802 VPWR VGND sg13g2_decap_8
XFILLER_15_798 VPWR VGND sg13g2_decap_8
X_326_ _491_/D _490_/Q _491_/Q _331_/S VPWR VGND sg13g2_mux2_1
XFILLER_46_378 VPWR VGND sg13g2_decap_8
Xfanout90 fanout90/X fanout92/X VPWR VGND sg13g2_buf_1
XFILLER_7_975 VPWR VGND sg13g2_decap_8
XFILLER_6_452 VPWR VGND sg13g2_decap_4
XFILLER_1_190 VPWR VGND sg13g2_fill_2
XFILLER_2_680 VPWR VGND sg13g2_decap_8
XFILLER_9_1005 VPWR VGND sg13g2_decap_8
XFILLER_0_617 VPWR VGND sg13g2_decap_8
XFILLER_47_1011 VPWR VGND sg13g2_decap_8
XFILLER_7_227 VPWR VGND sg13g2_fill_2
Xclkbuf_5_10__f_clk_regs _535_/CLK clkbuf_4_5_0_clk_regs/X VPWR VGND sg13g2_buf_16
XFILLER_4_956 VPWR VGND sg13g2_decap_8
XFILLER_35_805 VPWR VGND sg13g2_fill_2
XFILLER_47_676 VPWR VGND sg13g2_decap_8
X_309_ _474_/D _307_/A _307_/B _308_/Y VPWR VGND sg13g2_a21oi_1
XFILLER_7_772 VPWR VGND sg13g2_decap_8
XFILLER_6_282 VPWR VGND sg13g2_decap_4
XFILLER_26_805 VPWR VGND sg13g2_decap_8
Xclkbuf_5_29__f_clk_regs _563_/CLK clkbuf_4_14_0_clk_regs/X VPWR VGND sg13g2_buf_16
Xdelaybuf_22_clk delaybuf_23_clk/A delaybuf_22_clk/A VPWR VGND sg13g2_buf_16
XFILLER_1_948 VPWR VGND sg13g2_decap_8
Xdelaybuf_13_clk delaybuf_14_clk/A delaybuf_13_clk/A VPWR VGND sg13g2_buf_16
XFILLER_17_805 VPWR VGND sg13g2_decap_8
XFILLER_44_646 VPWR VGND sg13g2_decap_8
X_591_ _591_/Q _620_/CLK _591_/D fanout74/X VPWR VGND sg13g2_dfrbpq_1
X_660_ _660_/Q _660_/CLK _660_/D fanout80/X VPWR VGND sg13g2_dfrbpq_1
XFILLER_4_753 VPWR VGND sg13g2_decap_8
XFILLER_0_981 VPWR VGND sg13g2_decap_8
XFILLER_16_893 VPWR VGND sg13g2_decap_4
XFILLER_47_451 VPWR VGND sg13g2_decap_8
XFILLER_14_819 VPWR VGND sg13g2_decap_8
XFILLER_22_841 VPWR VGND sg13g2_decap_8
XFILLER_41_627 VPWR VGND sg13g2_decap_8
Xoutput34 uo_out[4] _289_/Y VPWR VGND sg13g2_buf_1
Xoutput23 uio_out[1] _243_/X VPWR VGND sg13g2_buf_1
XFILLER_0_255 VPWR VGND sg13g2_fill_1
XFILLER_1_745 VPWR VGND sg13g2_decap_8
XFILLER_49_738 VPWR VGND sg13g2_decap_8
X_574_ _574_/Q _577_/CLK _574_/D fanout82/X VPWR VGND sg13g2_dfrbpq_1
X_643_ _643_/Q _457_/Y _643_/D fanout76/X VPWR VGND sg13g2_dfrbpq_1
XFILLER_13_874 VPWR VGND sg13g2_decap_8
XFILLER_9_823 VPWR VGND sg13g2_decap_8
XFILLER_4_550 VPWR VGND sg13g2_decap_8
XFILLER_48_793 VPWR VGND sg13g2_decap_8
XFILLER_46_719 VPWR VGND sg13g2_decap_8
XFILLER_10_833 VPWR VGND sg13g2_decap_8
X_290_ _311_/S _602_/Q _291_/B VPWR VGND sg13g2_nor2b_1
XFILLER_1_542 VPWR VGND sg13g2_decap_8
XFILLER_49_524 VPWR VGND sg13g2_decap_8
XFILLER_45_785 VPWR VGND sg13g2_decap_8
X_557_ _557_/Q _557_/CLK _557_/D fanout98/X VPWR VGND sg13g2_dfrbpq_1
X_626_ _626_/Q _626_/CLK _626_/D fanout70/X VPWR VGND sg13g2_dfrbpq_1
X_488_ _488_/Q _505_/CLK _488_/D fanout91/X VPWR VGND sg13g2_dfrbpq_1
XFILLER_36_763 VPWR VGND sg13g2_decap_8
XFILLER_3_829 VPWR VGND sg13g2_decap_8
Xhold141 _653_/D _465_/Q VPWR VGND sg13g2_dlygate4sd3_1
Xhold130 _629_/D _600_/Q VPWR VGND sg13g2_dlygate4sd3_1
XFILLER_27_763 VPWR VGND sg13g2_decap_8
XFILLER_42_733 VPWR VGND sg13g2_decap_8
XFILLER_42_799 VPWR VGND sg13g2_decap_8
X_411_ _576_/D _575_/Q _576_/Q _412_/S VPWR VGND sg13g2_mux2_1
X_342_ _507_/D _506_/Q _507_/Q _429_/S VPWR VGND sg13g2_mux2_1
X_273_ _637_/D _273_/A0 _629_/Q _278_/S VPWR VGND sg13g2_mux2_1
XFILLER_6_656 VPWR VGND sg13g2_decap_8
XFILLER_2_862 VPWR VGND sg13g2_decap_8
XFILLER_49_321 VPWR VGND sg13g2_decap_8
XFILLER_18_763 VPWR VGND sg13g2_decap_8
XFILLER_45_582 VPWR VGND sg13g2_decap_8
X_609_ _609_/Q _613_/CLK _609_/D fanout73/X VPWR VGND sg13g2_dfrbpq_1
XFILLER_49_398 VPWR VGND sg13g2_decap_8
XFILLER_33_777 VPWR VGND sg13g2_decap_8
XFILLER_24_777 VPWR VGND sg13g2_decap_8
XFILLER_43_508 VPWR VGND sg13g2_fill_2
XFILLER_2_103 VPWR VGND sg13g2_fill_1
XFILLER_3_626 VPWR VGND sg13g2_decap_8
XFILLER_46_357 VPWR VGND sg13g2_decap_8
XFILLER_15_777 VPWR VGND sg13g2_decap_8
XFILLER_42_574 VPWR VGND sg13g2_decap_8
Xfanout80 fanout80/X fanout81/X VPWR VGND sg13g2_buf_1
Xfanout91 fanout91/X fanout92/X VPWR VGND sg13g2_buf_1
X_325_ _490_/D _489_/Q _490_/Q _331_/S VPWR VGND sg13g2_mux2_1
XFILLER_11_994 VPWR VGND sg13g2_decap_8
X_256_ _256_/Y _460_/A _256_/B VPWR VGND sg13g2_xnor2_1
XFILLER_7_954 VPWR VGND sg13g2_decap_8
XFILLER_38_847 VPWR VGND sg13g2_decap_4
Xclkbuf_5_28__f_clk_regs _515_/CLK clkbuf_4_14_0_clk_regs/X VPWR VGND sg13g2_buf_16
Xclkbuf_leaf_1_clk _256_/B clkload0/A VPWR VGND sg13g2_buf_8
XFILLER_9_1028 VPWR VGND sg13g2_fill_1
XFILLER_43_305 VPWR VGND sg13g2_fill_2
Xu_delay_line VPWR VGND u_delay_line/clk clkbuf_0_clk_delayed/A fanout95/X _566_/Q
+ _567_/Q _568_/Q _569_/Q _542_/Q _552_/Q _553_/Q _554_/Q _555_/Q _556_/Q _557_/Q
+ _558_/Q _559_/Q _560_/Q _561_/Q _543_/Q _562_/Q _563_/Q _564_/Q _565_/Q _544_/Q
+ _545_/Q _546_/Q _547_/Q _548_/Q _549_/Q _550_/Q _551_/Q delay_line
XFILLER_20_791 VPWR VGND sg13g2_decap_8
Xclkload0 clkload0/X clkload0/A VPWR VGND sg13g2_buf_8
XFILLER_7_239 VPWR VGND sg13g2_decap_8
XFILLER_4_935 VPWR VGND sg13g2_decap_8
XFILLER_11_791 VPWR VGND sg13g2_decap_8
X_308_ _308_/Y _473_/Q _307_/B _474_/Q VPWR VGND sg13g2_a21oi_1
X_239_ _239_/X _654_/Q _254_/B VPWR VGND sg13g2_and2_1
XFILLER_7_751 VPWR VGND sg13g2_decap_8
XFILLER_3_990 VPWR VGND sg13g2_decap_8
XFILLER_1_60 VPWR VGND sg13g2_fill_1
XFILLER_14_1022 VPWR VGND sg13g2_decap_8
XFILLER_1_927 VPWR VGND sg13g2_decap_8
XFILLER_44_625 VPWR VGND sg13g2_decap_8
X_590_ _590_/Q _623_/CLK _590_/D fanout74/X VPWR VGND sg13g2_dfrbpq_1
Xdelaybuf_6_clk delaybuf_7_clk/A delaybuf_6_clk/A VPWR VGND sg13g2_buf_16
XFILLER_4_732 VPWR VGND sg13g2_decap_8
XFILLER_0_960 VPWR VGND sg13g2_decap_8
XFILLER_47_430 VPWR VGND sg13g2_decap_8
XFILLER_16_861 VPWR VGND sg13g2_decap_8
XFILLER_22_820 VPWR VGND sg13g2_decap_8
XFILLER_1_724 VPWR VGND sg13g2_decap_8
Xoutput35 uo_out[5] _239_/X VPWR VGND sg13g2_buf_1
Xoutput24 uio_out[2] _244_/X VPWR VGND sg13g2_buf_1
X_642_ _642_/Q _456_/Y _642_/D fanout73/X VPWR VGND sg13g2_dfrbpq_1
XFILLER_49_717 VPWR VGND sg13g2_decap_8
XFILLER_13_853 VPWR VGND sg13g2_decap_8
XFILLER_44_433 VPWR VGND sg13g2_decap_8
XFILLER_44_466 VPWR VGND sg13g2_fill_2
X_573_ _573_/Q _577_/CLK _573_/D fanout82/X VPWR VGND sg13g2_dfrbpq_1
XFILLER_9_802 VPWR VGND sg13g2_decap_8
XFILLER_9_879 VPWR VGND sg13g2_decap_8
XFILLER_48_772 VPWR VGND sg13g2_decap_8
XFILLER_10_812 VPWR VGND sg13g2_decap_8
XFILLER_10_889 VPWR VGND sg13g2_decap_8
XFILLER_6_849 VPWR VGND sg13g2_decap_8
XFILLER_1_521 VPWR VGND sg13g2_decap_8
XFILLER_49_503 VPWR VGND sg13g2_decap_8
XFILLER_1_598 VPWR VGND sg13g2_decap_8
XFILLER_45_764 VPWR VGND sg13g2_decap_8
X_625_ _625_/Q _625_/CLK _625_/D fanout67/X VPWR VGND sg13g2_dfrbpq_1
X_556_ _556_/Q _557_/CLK _556_/D fanout97/X VPWR VGND sg13g2_dfrbpq_1
X_487_ _487_/Q _534_/CLK _487_/D fanout91/X VPWR VGND sg13g2_dfrbpq_1
XFILLER_48_591 VPWR VGND sg13g2_decap_8
XFILLER_3_808 VPWR VGND sg13g2_decap_8
Xhold142 _613_/D _586_/Q VPWR VGND sg13g2_dlygate4sd3_1
Xhold131 _262_/C _618_/Q VPWR VGND sg13g2_dlygate4sd3_1
Xhold120 _625_/D _596_/Q VPWR VGND sg13g2_dlygate4sd3_1
XFILLER_2_1023 VPWR VGND sg13g2_decap_4
XFILLER_46_517 VPWR VGND sg13g2_fill_2
XFILLER_42_712 VPWR VGND sg13g2_decap_8
X_410_ _575_/D _574_/Q _575_/Q _412_/S VPWR VGND sg13g2_mux2_1
X_341_ _506_/D _505_/Q _506_/Q _415_/S VPWR VGND sg13g2_mux2_1
X_272_ _272_/X _272_/A0 _628_/Q _278_/S VPWR VGND sg13g2_mux2_1
XFILLER_6_635 VPWR VGND sg13g2_decap_8
XFILLER_2_841 VPWR VGND sg13g2_decap_8
Xclkbuf_5_27__f_clk_regs _620_/CLK clkbuf_4_13_0_clk_regs/X VPWR VGND sg13g2_buf_16
XFILLER_49_300 VPWR VGND sg13g2_decap_8
XFILLER_33_756 VPWR VGND sg13g2_decap_8
XFILLER_45_561 VPWR VGND sg13g2_decap_8
X_608_ _608_/Q _616_/CLK _608_/D fanout73/X VPWR VGND sg13g2_dfrbpq_1
XFILLER_49_377 VPWR VGND sg13g2_decap_8
X_539_ _539_/Q _626_/CLK _539_/D fanout70/X VPWR VGND sg13g2_dfrbpq_1
XFILLER_4_82 VPWR VGND sg13g2_fill_2
XFILLER_24_756 VPWR VGND sg13g2_decap_8
XFILLER_3_605 VPWR VGND sg13g2_decap_8
XFILLER_2_159 VPWR VGND sg13g2_fill_1
XFILLER_46_336 VPWR VGND sg13g2_decap_8
XFILLER_47_837 VPWR VGND sg13g2_decap_8
XFILLER_11_973 VPWR VGND sg13g2_decap_8
XFILLER_15_756 VPWR VGND sg13g2_decap_8
Xfanout70 fanout70/X fanout72/X VPWR VGND sg13g2_buf_1
Xfanout81 fanout81/X fanout84/X VPWR VGND sg13g2_buf_1
Xfanout92 fanout92/X fanout93/X VPWR VGND sg13g2_buf_1
X_324_ _489_/D _488_/Q _489_/Q _415_/S VPWR VGND sg13g2_mux2_1
X_255_ _255_/X _645_/Q _255_/B VPWR VGND sg13g2_and2_1
XFILLER_7_933 VPWR VGND sg13g2_decap_8
XFILLER_38_826 VPWR VGND sg13g2_decap_8
XFILLER_44_829 VPWR VGND sg13g2_decap_8
XFILLER_20_770 VPWR VGND sg13g2_decap_8
Xclkload1 clkload1/Y _449_/B VPWR VGND sg13g2_inv_4
XFILLER_3_402 VPWR VGND sg13g2_decap_4
XFILLER_3_479 VPWR VGND sg13g2_decap_8
XFILLER_4_914 VPWR VGND sg13g2_decap_8
XFILLER_47_634 VPWR VGND sg13g2_decap_8
XFILLER_43_840 VPWR VGND sg13g2_decap_8
XFILLER_43_851 VPWR VGND sg13g2_fill_1
XFILLER_11_770 VPWR VGND sg13g2_decap_8
X_307_ _310_/B _307_/A _307_/B VPWR VGND sg13g2_nand2_1
X_238_ _258_/A _254_/B VPWR VGND sg13g2_inv_1
XFILLER_7_730 VPWR VGND sg13g2_decap_8
XFILLER_1_906 VPWR VGND sg13g2_decap_8
XFILLER_0_449 VPWR VGND sg13g2_decap_8
XFILLER_29_13 VPWR VGND sg13g2_fill_1
XFILLER_48_409 VPWR VGND sg13g2_decap_8
XFILLER_25_840 VPWR VGND sg13g2_decap_8
XFILLER_25_851 VPWR VGND sg13g2_fill_1
XFILLER_44_604 VPWR VGND sg13g2_decap_8
Xclkbuf_4_8_0_clk_regs clkbuf_4_8_0_clk_regs/X clkbuf_0_clk_regs/X VPWR VGND sg13g2_buf_8
XFILLER_4_788 VPWR VGND sg13g2_decap_8
XFILLER_4_711 VPWR VGND sg13g2_decap_8
XFILLER_47_486 VPWR VGND sg13g2_decap_8
XFILLER_16_840 VPWR VGND sg13g2_decap_8
XFILLER_5_519 VPWR VGND sg13g2_decap_8
XFILLER_1_703 VPWR VGND sg13g2_decap_8
Xoutput36 uo_out[6] _240_/X VPWR VGND sg13g2_buf_1
Xoutput25 uio_out[3] _245_/X VPWR VGND sg13g2_buf_1
Xoutput14 uio_oe[0] _249_/X VPWR VGND sg13g2_buf_1
XFILLER_44_412 VPWR VGND sg13g2_decap_8
X_572_ _572_/Q _577_/CLK _572_/D fanout83/X VPWR VGND sg13g2_dfrbpq_1
X_641_ _641_/Q _455_/Y _641_/D fanout86/X VPWR VGND sg13g2_dfrbpq_1
XFILLER_13_832 VPWR VGND sg13g2_decap_8
XFILLER_9_858 VPWR VGND sg13g2_decap_8
XFILLER_4_585 VPWR VGND sg13g2_decap_8
XFILLER_48_751 VPWR VGND sg13g2_decap_8
XFILLER_47_283 VPWR VGND sg13g2_decap_8
XFILLER_11_1015 VPWR VGND sg13g2_decap_8
XFILLER_39_784 VPWR VGND sg13g2_decap_8
XFILLER_41_415 VPWR VGND sg13g2_decap_4
XFILLER_10_868 VPWR VGND sg13g2_decap_8
XFILLER_6_828 VPWR VGND sg13g2_decap_8
XFILLER_1_500 VPWR VGND sg13g2_decap_8
XFILLER_1_577 VPWR VGND sg13g2_decap_8
Xclkbuf_5_26__f_clk_regs _593_/CLK clkbuf_4_13_0_clk_regs/X VPWR VGND sg13g2_buf_16
XFILLER_45_743 VPWR VGND sg13g2_decap_8
X_555_ _555_/Q _557_/CLK _555_/D fanout97/X VPWR VGND sg13g2_dfrbpq_1
X_624_ _624_/Q _625_/CLK _624_/D fanout67/X VPWR VGND sg13g2_dfrbpq_1
XFILLER_49_559 VPWR VGND sg13g2_decap_8
X_486_ _486_/Q _534_/CLK _486_/D fanout92/X VPWR VGND sg13g2_dfrbpq_1
XFILLER_5_883 VPWR VGND sg13g2_decap_8
XFILLER_48_570 VPWR VGND sg13g2_decap_8
XFILLER_17_990 VPWR VGND sg13g2_fill_2
XFILLER_36_798 VPWR VGND sg13g2_decap_8
Xhold110 _630_/D _601_/Q VPWR VGND sg13g2_dlygate4sd3_1
Xhold143 _621_/D _592_/Q VPWR VGND sg13g2_dlygate4sd3_1
Xhold132 _627_/D _598_/Q VPWR VGND sg13g2_dlygate4sd3_1
Xhold121 _611_/D _584_/Q VPWR VGND sg13g2_dlygate4sd3_1
XFILLER_2_1002 VPWR VGND sg13g2_decap_8
XFILLER_27_798 VPWR VGND sg13g2_decap_8
XFILLER_42_768 VPWR VGND sg13g2_decap_8
X_340_ _505_/D _504_/Q _505_/Q _416_/S VPWR VGND sg13g2_mux2_1
X_271_ _271_/X _271_/A0 _627_/Q _278_/S VPWR VGND sg13g2_mux2_1
XFILLER_2_820 VPWR VGND sg13g2_decap_8
XFILLER_6_614 VPWR VGND sg13g2_decap_8
XFILLER_2_897 VPWR VGND sg13g2_decap_8
XFILLER_49_356 VPWR VGND sg13g2_decap_8
XFILLER_18_798 VPWR VGND sg13g2_decap_8
X_607_ _607_/Q _621_/CLK _607_/D fanout86/X VPWR VGND sg13g2_dfrbpq_1
X_538_ _538_/Q _612_/CLK _538_/D fanout70/X VPWR VGND sg13g2_dfrbpq_1
X_469_ _469_/Q _659_/CLK _469_/D fanout81/X VPWR VGND sg13g2_dfrbpq_1
XFILLER_5_680 VPWR VGND sg13g2_decap_8
Xclkbuf_4_10_0_clk_regs clkbuf_4_10_0_clk_regs/X clkbuf_0_clk_regs/X VPWR VGND sg13g2_buf_8
XFILLER_2_138 VPWR VGND sg13g2_fill_2
XFILLER_46_315 VPWR VGND sg13g2_decap_8
XFILLER_47_816 VPWR VGND sg13g2_decap_8
XFILLER_11_952 VPWR VGND sg13g2_decap_8
XFILLER_30_749 VPWR VGND sg13g2_decap_8
Xfanout60 _392_/S fanout61/X VPWR VGND sg13g2_buf_1
Xfanout71 fanout71/X fanout72/X VPWR VGND sg13g2_buf_1
Xfanout82 fanout82/X fanout84/X VPWR VGND sg13g2_buf_1
Xfanout93 fanout93/X input1/X VPWR VGND sg13g2_buf_1
X_323_ _488_/D _487_/Q _488_/Q _323_/S VPWR VGND sg13g2_mux2_1
X_254_ _254_/X _643_/Q _254_/B VPWR VGND sg13g2_and2_1
XFILLER_7_912 VPWR VGND sg13g2_decap_8
XFILLER_1_160 VPWR VGND sg13g2_fill_2
XFILLER_2_694 VPWR VGND sg13g2_decap_8
XFILLER_9_1019 VPWR VGND sg13g2_decap_8
XFILLER_7_989 VPWR VGND sg13g2_decap_8
XFILLER_38_805 VPWR VGND sg13g2_decap_8
XFILLER_21_749 VPWR VGND sg13g2_decap_8
XFILLER_45_381 VPWR VGND sg13g2_decap_8
Xdelaybuf_25_clk delaybuf_26_clk/A delaybuf_25_clk/A VPWR VGND sg13g2_buf_16
XFILLER_29_805 VPWR VGND sg13g2_decap_8
XFILLER_47_1025 VPWR VGND sg13g2_decap_4
XFILLER_43_307 VPWR VGND sg13g2_fill_1
XFILLER_44_808 VPWR VGND sg13g2_decap_8
XFILLER_12_749 VPWR VGND sg13g2_decap_4
Xclkload2 clkload2/Y _440_/B VPWR VGND sg13g2_inv_4
Xdelaybuf_16_clk delaybuf_16_clk/X delaybuf_16_clk/A VPWR VGND sg13g2_buf_16
XFILLER_47_613 VPWR VGND sg13g2_decap_8
X_306_ _473_/D _473_/Q _307_/B VPWR VGND sg13g2_xor2_1
X_237_ _255_/B _281_/A _279_/B VPWR VGND sg13g2_and2_1
XFILLER_7_786 VPWR VGND sg13g2_decap_8
XFILLER_2_491 VPWR VGND sg13g2_decap_8
XFILLER_26_819 VPWR VGND sg13g2_decap_8
XFILLER_0_428 VPWR VGND sg13g2_decap_8
XFILLER_17_819 VPWR VGND sg13g2_decap_8
XFILLER_40_833 VPWR VGND sg13g2_decap_8
XFILLER_4_767 VPWR VGND sg13g2_decap_8
XFILLER_0_995 VPWR VGND sg13g2_decap_8
XFILLER_47_465 VPWR VGND sg13g2_decap_8
XFILLER_31_844 VPWR VGND sg13g2_decap_8
XFILLER_43_693 VPWR VGND sg13g2_decap_8
XFILLER_7_583 VPWR VGND sg13g2_decap_8
XFILLER_25_0 VPWR VGND sg13g2_fill_1
Xclkbuf_5_25__f_clk_regs _513_/CLK clkbuf_4_12_0_clk_regs/X VPWR VGND sg13g2_buf_16
XFILLER_1_759 VPWR VGND sg13g2_decap_8
Xoutput37 uo_out[7] _241_/X VPWR VGND sg13g2_buf_1
Xoutput26 uio_out[4] _248_/B VPWR VGND sg13g2_buf_1
Xoutput15 uio_oe[1] _250_/X VPWR VGND sg13g2_buf_1
X_571_ _571_/Q _577_/CLK _571_/D fanout83/X VPWR VGND sg13g2_dfrbpq_1
X_640_ _640_/Q _454_/Y _640_/D fanout86/X VPWR VGND sg13g2_dfrbpq_1
XFILLER_13_811 VPWR VGND sg13g2_decap_8
XFILLER_13_888 VPWR VGND sg13g2_decap_8
XFILLER_44_468 VPWR VGND sg13g2_fill_1
XFILLER_44_479 VPWR VGND sg13g2_decap_4
XFILLER_9_837 VPWR VGND sg13g2_decap_8
XFILLER_4_564 VPWR VGND sg13g2_decap_8
XFILLER_0_792 VPWR VGND sg13g2_decap_8
XFILLER_48_730 VPWR VGND sg13g2_decap_8
Xclkbuf_0_clk_delayed clkbuf_0_clk_delayed/X clkbuf_0_clk_delayed/A VPWR VGND sg13g2_buf_16
XFILLER_8_881 VPWR VGND sg13g2_decap_8
XFILLER_39_763 VPWR VGND sg13g2_decap_8
Xclkbuf_5_9__f_clk_regs _511_/CLK clkbuf_4_4_0_clk_regs/X VPWR VGND sg13g2_buf_16
XFILLER_10_847 VPWR VGND sg13g2_decap_8
XFILLER_6_807 VPWR VGND sg13g2_decap_8
XFILLER_1_556 VPWR VGND sg13g2_decap_8
XFILLER_49_538 VPWR VGND sg13g2_decap_8
XFILLER_45_722 VPWR VGND sg13g2_decap_8
XFILLER_45_799 VPWR VGND sg13g2_decap_8
X_554_ _554_/Q _570_/CLK _554_/D fanout97/X VPWR VGND sg13g2_dfrbpq_1
X_623_ _623_/Q _623_/CLK _623_/D fanout73/X VPWR VGND sg13g2_dfrbpq_1
X_485_ _485_/Q _570_/CLK _485_/D fanout92/X VPWR VGND sg13g2_dfrbpq_1
XFILLER_5_862 VPWR VGND sg13g2_decap_8
XFILLER_36_777 VPWR VGND sg13g2_decap_8
Xhold144 _276_/A0 _610_/Q VPWR VGND sg13g2_dlygate4sd3_1
Xhold133 _272_/A0 _614_/Q VPWR VGND sg13g2_dlygate4sd3_1
Xhold122 _620_/D _591_/Q VPWR VGND sg13g2_dlygate4sd3_1
Xhold111 _271_/A0 _613_/Q VPWR VGND sg13g2_dlygate4sd3_1
X_257__100 _647_/CLK _257__99/A VPWR VGND sg13g2_inv_1
XFILLER_27_777 VPWR VGND sg13g2_decap_8
XFILLER_42_747 VPWR VGND sg13g2_decap_8
X_270_ _642_/D _608_/Q _622_/Q _270_/S VPWR VGND sg13g2_mux2_1
XFILLER_2_876 VPWR VGND sg13g2_decap_8
XFILLER_5_158 VPWR VGND sg13g2_fill_2
XFILLER_49_335 VPWR VGND sg13g2_decap_8
XFILLER_14_994 VPWR VGND sg13g2_fill_1
XFILLER_18_777 VPWR VGND sg13g2_decap_8
XFILLER_45_596 VPWR VGND sg13g2_decap_8
X_606_ _606_/Q _620_/CLK _606_/D fanout85/X VPWR VGND sg13g2_dfrbpq_1
X_537_ _537_/Q _613_/CLK _537_/D fanout75/X VPWR VGND sg13g2_dfrbpq_1
X_468_ _656_/D _444_/Y _468_/D fanout78/X VPWR VGND sg13g2_dfrbpq_1
X_399_ _564_/D _563_/Q _564_/Q _404_/S VPWR VGND sg13g2_mux2_1
Xclkbuf_leaf_4_clk _456_/B delaybuf_16_clk/A VPWR VGND sg13g2_buf_8
XFILLER_4_84 VPWR VGND sg13g2_fill_1
XFILLER_12_909 VPWR VGND sg13g2_decap_8
XFILLER_32_791 VPWR VGND sg13g2_decap_8
XFILLER_42_588 VPWR VGND sg13g2_fill_2
X_322_ _487_/D _486_/Q _487_/Q _323_/S VPWR VGND sg13g2_mux2_1
XFILLER_11_931 VPWR VGND sg13g2_decap_8
Xfanout50 _415_/S _416_/S VPWR VGND sg13g2_buf_1
Xfanout61 fanout61/X _291_/Y VPWR VGND sg13g2_buf_1
Xfanout72 fanout72/X fanout93/X VPWR VGND sg13g2_buf_1
Xfanout83 fanout83/X fanout84/X VPWR VGND sg13g2_buf_1
Xfanout94 fanout94/X fanout95/X VPWR VGND sg13g2_buf_1
X_253_ _253_/X _634_/Q _254_/B VPWR VGND sg13g2_and2_1
XFILLER_7_968 VPWR VGND sg13g2_decap_8
XFILLER_6_467 VPWR VGND sg13g2_fill_1
XFILLER_6_456 VPWR VGND sg13g2_fill_1
XFILLER_2_673 VPWR VGND sg13g2_decap_8
XFILLER_45_360 VPWR VGND sg13g2_decap_8
XFILLER_14_791 VPWR VGND sg13g2_decap_8
Xclkload20 clkload20/Y _459_/A VPWR VGND sg13g2_inv_4
Xclkload3 clkload3/Y _541_/CLK VPWR VGND sg13g2_inv_1
XFILLER_4_949 VPWR VGND sg13g2_decap_8
XFILLER_46_179 VPWR VGND sg13g2_fill_1
Xdelaybuf_9_clk delaybuf_9_clk/X delaybuf_9_clk/A VPWR VGND sg13g2_buf_16
X_305_ _472_/D _220_/Y _301_/Y _307_/B VPWR VGND sg13g2_a21oi_1
X_236_ _461_/D _236_/A0 _461_/Q _236_/S VPWR VGND sg13g2_mux2_1
XFILLER_7_765 VPWR VGND sg13g2_decap_8
XFILLER_6_286 VPWR VGND sg13g2_fill_1
XFILLER_2_470 VPWR VGND sg13g2_decap_8
XFILLER_46_691 VPWR VGND sg13g2_decap_8
Xclkbuf_5_24__f_clk_regs _621_/CLK clkbuf_4_12_0_clk_regs/X VPWR VGND sg13g2_buf_16
XFILLER_44_639 VPWR VGND sg13g2_decap_8
XFILLER_40_812 VPWR VGND sg13g2_decap_8
XFILLER_4_746 VPWR VGND sg13g2_decap_8
XFILLER_0_974 VPWR VGND sg13g2_decap_8
XFILLER_10_61 VPWR VGND sg13g2_fill_1
XFILLER_10_72 VPWR VGND sg13g2_fill_1
XFILLER_48_912 VPWR VGND sg13g2_decap_8
XFILLER_16_886 VPWR VGND sg13g2_decap_8
XFILLER_43_672 VPWR VGND sg13g2_decap_8
XFILLER_47_444 VPWR VGND sg13g2_decap_8
XFILLER_16_897 VPWR VGND sg13g2_fill_1
X_219_ _304_/A _470_/Q VPWR VGND sg13g2_inv_1
XFILLER_7_562 VPWR VGND sg13g2_decap_8
XFILLER_22_834 VPWR VGND sg13g2_decap_8
Xclkbuf_5_8__f_clk_regs _505_/CLK clkbuf_4_4_0_clk_regs/X VPWR VGND sg13g2_buf_16
XFILLER_1_738 VPWR VGND sg13g2_decap_8
Xoutput27 uio_out[5] _246_/X VPWR VGND sg13g2_buf_1
Xoutput16 uio_oe[2] _251_/X VPWR VGND sg13g2_buf_1
XFILLER_5_1023 VPWR VGND sg13g2_decap_4
X_570_ _570_/Q _570_/CLK _570_/D fanout97/X VPWR VGND sg13g2_dfrbpq_1
XFILLER_13_867 VPWR VGND sg13g2_decap_8
XFILLER_9_816 VPWR VGND sg13g2_decap_8
XFILLER_4_543 VPWR VGND sg13g2_decap_8
XFILLER_0_771 VPWR VGND sg13g2_decap_8
XFILLER_48_786 VPWR VGND sg13g2_decap_8
Xclkbuf_0_clk clkbuf_0_clk/X clk VPWR VGND sg13g2_buf_16
XFILLER_8_860 VPWR VGND sg13g2_decap_8
XFILLER_7_95 VPWR VGND sg13g2_fill_2
XFILLER_10_826 VPWR VGND sg13g2_decap_8
XFILLER_1_535 VPWR VGND sg13g2_decap_8
XFILLER_45_701 VPWR VGND sg13g2_decap_8
X_622_ _622_/Q _623_/CLK _622_/D fanout73/X VPWR VGND sg13g2_dfrbpq_1
XFILLER_49_517 VPWR VGND sg13g2_decap_8
XFILLER_45_778 VPWR VGND sg13g2_decap_8
X_553_ _553_/Q _569_/CLK _553_/D fanout96/X VPWR VGND sg13g2_dfrbpq_1
X_484_ _484_/Q _569_/CLK _484_/D fanout98/X VPWR VGND sg13g2_dfrbpq_1
XFILLER_5_841 VPWR VGND sg13g2_decap_8
XFILLER_4_362 VPWR VGND sg13g2_decap_8
XFILLER_36_756 VPWR VGND sg13g2_decap_8
Xhold145 _277_/A0 _611_/Q VPWR VGND sg13g2_dlygate4sd3_1
Xhold134 _636_/D _272_/X VPWR VGND sg13g2_dlygate4sd3_1
Xhold123 _614_/D _587_/Q VPWR VGND sg13g2_dlygate4sd3_1
Xhold112 _635_/D _271_/X VPWR VGND sg13g2_dlygate4sd3_1
Xhold101 _259_/B _644_/Q VPWR VGND sg13g2_dlygate4sd3_1
XFILLER_27_756 VPWR VGND sg13g2_decap_8
XFILLER_42_726 VPWR VGND sg13g2_decap_8
XFILLER_6_649 VPWR VGND sg13g2_decap_8
XFILLER_2_855 VPWR VGND sg13g2_decap_8
Xclkbuf_2_3__f_clk_delayed _459_/A clkbuf_0_clk_delayed/X VPWR VGND sg13g2_buf_16
XFILLER_49_314 VPWR VGND sg13g2_decap_8
XFILLER_18_756 VPWR VGND sg13g2_decap_8
XFILLER_45_520 VPWR VGND sg13g2_decap_4
X_605_ _605_/Q _623_/CLK _605_/D fanout74/X VPWR VGND sg13g2_dfrbpq_1
XFILLER_41_792 VPWR VGND sg13g2_decap_8
XFILLER_45_575 VPWR VGND sg13g2_decap_8
X_536_ _536_/Q _593_/CLK _536_/D fanout75/X VPWR VGND sg13g2_dfrbpq_1
X_467_ _655_/D _443_/Y _467_/D fanout78/X VPWR VGND sg13g2_dfrbpq_1
X_398_ _563_/D _562_/Q _563_/Q _398_/S VPWR VGND sg13g2_mux2_1
XFILLER_49_892 VPWR VGND sg13g2_decap_8
XFILLER_32_770 VPWR VGND sg13g2_decap_8
XFILLER_3_619 VPWR VGND sg13g2_decap_8
XFILLER_11_910 VPWR VGND sg13g2_decap_8
XFILLER_23_770 VPWR VGND sg13g2_decap_4
XFILLER_42_567 VPWR VGND sg13g2_decap_8
Xfanout40 _436_/S _432_/S VPWR VGND sg13g2_buf_1
Xfanout51 _416_/S _321_/S VPWR VGND sg13g2_buf_1
Xfanout62 _248_/B _254_/B VPWR VGND sg13g2_buf_1
Xfanout73 fanout73/X fanout75/X VPWR VGND sg13g2_buf_1
X_321_ _486_/D _485_/Q _486_/Q _321_/S VPWR VGND sg13g2_mux2_1
X_252_ _252_/X _633_/Q _252_/B VPWR VGND sg13g2_and2_1
XFILLER_11_987 VPWR VGND sg13g2_decap_8
Xfanout84 fanout84/X fanout93/X VPWR VGND sg13g2_buf_1
Xfanout95 fanout95/X fanout98/X VPWR VGND sg13g2_buf_1
XFILLER_7_947 VPWR VGND sg13g2_decap_8
XFILLER_6_413 VPWR VGND sg13g2_fill_2
XFILLER_6_402 VPWR VGND sg13g2_fill_1
XFILLER_1_162 VPWR VGND sg13g2_fill_1
XFILLER_2_652 VPWR VGND sg13g2_decap_8
XFILLER_14_770 VPWR VGND sg13g2_decap_8
Xclkbuf_5_23__f_clk_regs _623_/CLK clkbuf_4_11_0_clk_regs/X VPWR VGND sg13g2_buf_16
Xclkload10 clkload10/Y _613_/CLK VPWR VGND sg13g2_inv_1
X_519_ _519_/Q _535_/CLK _519_/D fanout83/X VPWR VGND sg13g2_dfrbpq_1
XFILLER_5_490 VPWR VGND sg13g2_fill_2
XFILLER_20_784 VPWR VGND sg13g2_decap_8
Xclkload4 clkload4/Y _657_/CLK VPWR VGND sg13g2_inv_1
XFILLER_4_928 VPWR VGND sg13g2_decap_8
XFILLER_47_648 VPWR VGND sg13g2_fill_2
XFILLER_11_784 VPWR VGND sg13g2_decap_8
XFILLER_42_342 VPWR VGND sg13g2_fill_2
X_304_ _307_/B _304_/A _366_/S _304_/C VPWR VGND sg13g2_nor3_1
X_235_ _462_/D _235_/A0 _658_/D _236_/S VPWR VGND sg13g2_mux2_1
XFILLER_3_983 VPWR VGND sg13g2_decap_8
XFILLER_7_744 VPWR VGND sg13g2_decap_8
XFILLER_1_20 VPWR VGND sg13g2_fill_2
Xclkbuf_5_7__f_clk_regs _660_/CLK clkbuf_4_3_0_clk_regs/X VPWR VGND sg13g2_buf_16
XFILLER_34_810 VPWR VGND sg13g2_decap_4
XFILLER_46_670 VPWR VGND sg13g2_decap_8
XFILLER_44_618 VPWR VGND sg13g2_decap_8
XFILLER_3_257 VPWR VGND sg13g2_fill_2
XFILLER_4_725 VPWR VGND sg13g2_decap_8
XFILLER_0_953 VPWR VGND sg13g2_decap_8
Xclkbuf_regs_0_clk clkbuf_regs_0_clk/X delaybuf_29_clk/X VPWR VGND sg13g2_buf_16
XFILLER_47_423 VPWR VGND sg13g2_decap_8
XFILLER_16_854 VPWR VGND sg13g2_decap_8
XFILLER_43_651 VPWR VGND sg13g2_decap_8
X_218_ _218_/Y _469_/Q VPWR VGND sg13g2_inv_1
XFILLER_7_541 VPWR VGND sg13g2_decap_8
XFILLER_3_780 VPWR VGND sg13g2_decap_8
XFILLER_22_813 VPWR VGND sg13g2_decap_8
XFILLER_1_717 VPWR VGND sg13g2_decap_8
Xoutput28 uio_out[6] _247_/X VPWR VGND sg13g2_buf_1
Xoutput17 uio_oe[3] _252_/X VPWR VGND sg13g2_buf_1
XFILLER_5_1002 VPWR VGND sg13g2_decap_8
XFILLER_44_426 VPWR VGND sg13g2_decap_8
XFILLER_13_846 VPWR VGND sg13g2_decap_8
XFILLER_0_750 VPWR VGND sg13g2_decap_8
XFILLER_4_599 VPWR VGND sg13g2_decap_8
XFILLER_4_522 VPWR VGND sg13g2_decap_8
XFILLER_48_765 VPWR VGND sg13g2_decap_8
XFILLER_47_297 VPWR VGND sg13g2_decap_8
XFILLER_39_798 VPWR VGND sg13g2_decap_8
Xclkbuf_4_7_0_clk_regs clkbuf_4_7_0_clk_regs/X clkbuf_0_clk_regs/X VPWR VGND sg13g2_buf_8
XFILLER_10_805 VPWR VGND sg13g2_decap_8
XFILLER_1_514 VPWR VGND sg13g2_decap_8
X_621_ _621_/Q _621_/CLK _621_/D fanout85/X VPWR VGND sg13g2_dfrbpq_1
XFILLER_16_72 VPWR VGND sg13g2_fill_1
XFILLER_45_757 VPWR VGND sg13g2_decap_8
X_552_ _552_/Q _567_/CLK _552_/D fanout96/X VPWR VGND sg13g2_dfrbpq_1
X_483_ _483_/Q _569_/CLK _483_/D fanout98/X VPWR VGND sg13g2_dfrbpq_1
XFILLER_5_820 VPWR VGND sg13g2_decap_8
XFILLER_5_897 VPWR VGND sg13g2_decap_8
XFILLER_48_584 VPWR VGND sg13g2_decap_8
Xhold135 _278_/A0 _612_/Q VPWR VGND sg13g2_dlygate4sd3_1
Xhold124 _608_/D _581_/Q VPWR VGND sg13g2_dlygate4sd3_1
Xhold113 _659_/D _463_/Q VPWR VGND sg13g2_dlygate4sd3_1
Xhold102 _648_/D _259_/X VPWR VGND sg13g2_dlygate4sd3_1
XFILLER_2_1016 VPWR VGND sg13g2_decap_8
XFILLER_2_1027 VPWR VGND sg13g2_fill_2
XFILLER_42_705 VPWR VGND sg13g2_decap_8
XFILLER_6_628 VPWR VGND sg13g2_decap_8
XFILLER_5_116 VPWR VGND sg13g2_fill_2
XFILLER_2_834 VPWR VGND sg13g2_decap_8
XFILLER_45_554 VPWR VGND sg13g2_decap_8
X_604_ _604_/Q _618_/CLK _604_/D fanout77/X VPWR VGND sg13g2_dfrbpq_1
X_535_ _535_/Q _535_/CLK _535_/D fanout82/X VPWR VGND sg13g2_dfrbpq_1
XFILLER_14_952 VPWR VGND sg13g2_decap_4
XFILLER_33_749 VPWR VGND sg13g2_decap_8
XFILLER_41_771 VPWR VGND sg13g2_decap_8
Xclkbuf_5_22__f_clk_regs _630_/CLK clkbuf_4_11_0_clk_regs/X VPWR VGND sg13g2_buf_16
X_466_ _654_/D _442_/Y _466_/D fanout78/X VPWR VGND sg13g2_dfrbpq_1
X_397_ _562_/D _561_/Q _562_/Q _397_/S VPWR VGND sg13g2_mux2_1
XFILLER_5_694 VPWR VGND sg13g2_decap_8
XFILLER_49_871 VPWR VGND sg13g2_decap_8
XFILLER_24_749 VPWR VGND sg13g2_decap_8
XFILLER_48_381 VPWR VGND sg13g2_decap_8
Xdelaybuf_28_clk delaybuf_29_clk/A delaybuf_28_clk/A VPWR VGND sg13g2_buf_16
XFILLER_46_329 VPWR VGND sg13g2_decap_8
XFILLER_11_966 VPWR VGND sg13g2_decap_8
XFILLER_15_749 VPWR VGND sg13g2_decap_8
Xfanout41 _432_/S fanout46/X VPWR VGND sg13g2_buf_1
Xfanout52 _350_/S _331_/S VPWR VGND sg13g2_buf_1
Xfanout63 _252_/B _254_/B VPWR VGND sg13g2_buf_1
Xfanout74 fanout74/X fanout75/X VPWR VGND sg13g2_buf_1
Xfanout85 fanout85/X fanout87/X VPWR VGND sg13g2_buf_1
Xfanout96 fanout96/X fanout97/X VPWR VGND sg13g2_buf_1
X_320_ _485_/D _484_/Q _485_/Q _323_/S VPWR VGND sg13g2_mux2_1
X_251_ _251_/X _632_/Q _252_/B VPWR VGND sg13g2_and2_1
XFILLER_7_926 VPWR VGND sg13g2_decap_8
XFILLER_2_631 VPWR VGND sg13g2_decap_8
Xdelaybuf_19_clk delaybuf_20_clk/A delaybuf_19_clk/A VPWR VGND sg13g2_buf_16
XFILLER_38_819 VPWR VGND sg13g2_decap_8
Xclkbuf_5_6__f_clk_regs _658_/CLK clkbuf_4_3_0_clk_regs/X VPWR VGND sg13g2_buf_16
XFILLER_45_395 VPWR VGND sg13g2_decap_8
X_518_ _518_/Q _657_/CLK _518_/D fanout81/X VPWR VGND sg13g2_dfrbpq_1
Xclkload11 clkload11/Y _612_/CLK VPWR VGND sg13g2_inv_1
X_449_ _449_/Y _456_/A _449_/B VPWR VGND sg13g2_xnor2_1
XFILLER_29_819 VPWR VGND sg13g2_decap_4
Xclkload5 clkload5/Y _577_/CLK VPWR VGND sg13g2_inv_1
XFILLER_20_763 VPWR VGND sg13g2_decap_8
XFILLER_4_907 VPWR VGND sg13g2_decap_8
XFILLER_8_1000 VPWR VGND sg13g2_decap_4
XFILLER_47_627 VPWR VGND sg13g2_decap_8
XFILLER_43_833 VPWR VGND sg13g2_decap_8
XFILLER_11_763 VPWR VGND sg13g2_decap_8
X_303_ _304_/C _469_/Q _471_/Q _472_/Q VPWR VGND sg13g2_nand3_1
X_234_ _463_/D _234_/A0 _463_/Q _236_/S VPWR VGND sg13g2_mux2_1
XFILLER_7_723 VPWR VGND sg13g2_decap_8
XFILLER_3_962 VPWR VGND sg13g2_decap_8
XFILLER_6_299 VPWR VGND sg13g2_fill_1
XFILLER_25_833 VPWR VGND sg13g2_decap_8
Xclkbuf_0__017__regs clkbuf_0__017__regs/X clkbuf_regs_1_clk/X VPWR VGND sg13g2_buf_16
XFILLER_40_847 VPWR VGND sg13g2_decap_4
XFILLER_0_932 VPWR VGND sg13g2_decap_8
XFILLER_4_704 VPWR VGND sg13g2_decap_8
XFILLER_47_479 VPWR VGND sg13g2_decap_8
XFILLER_47_402 VPWR VGND sg13g2_decap_8
XFILLER_16_833 VPWR VGND sg13g2_decap_8
XFILLER_43_630 VPWR VGND sg13g2_decap_8
XFILLER_7_597 VPWR VGND sg13g2_decap_8
XFILLER_7_520 VPWR VGND sg13g2_decap_8
Xoutput29 uio_out[7] _248_/X VPWR VGND sg13g2_buf_1
Xoutput18 uio_oe[4] _253_/X VPWR VGND sg13g2_buf_1
XFILLER_44_405 VPWR VGND sg13g2_decap_8
XFILLER_13_825 VPWR VGND sg13g2_decap_8
XFILLER_4_501 VPWR VGND sg13g2_decap_8
XFILLER_4_578 VPWR VGND sg13g2_decap_8
XFILLER_48_744 VPWR VGND sg13g2_decap_8
XFILLER_11_1008 VPWR VGND sg13g2_decap_8
XFILLER_8_895 VPWR VGND sg13g2_decap_8
XFILLER_7_97 VPWR VGND sg13g2_fill_1
XFILLER_39_777 VPWR VGND sg13g2_decap_8
XFILLER_45_736 VPWR VGND sg13g2_decap_8
X_620_ _620_/Q _620_/CLK _620_/D fanout85/X VPWR VGND sg13g2_dfrbpq_1
X_551_ _551_/Q _562_/CLK _551_/D fanout95/X VPWR VGND sg13g2_dfrbpq_1
Xclkbuf_5_21__f_clk_regs _616_/CLK clkbuf_4_10_0_clk_regs/X VPWR VGND sg13g2_buf_16
X_482_ _482_/Q _569_/CLK _482_/D fanout98/X VPWR VGND sg13g2_dfrbpq_1
XFILLER_5_876 VPWR VGND sg13g2_decap_8
XFILLER_4_331 VPWR VGND sg13g2_decap_4
XFILLER_48_563 VPWR VGND sg13g2_decap_8
Xhold136 _634_/D _278_/X VPWR VGND sg13g2_dlygate4sd3_1
Xhold125 _622_/D _593_/Q VPWR VGND sg13g2_dlygate4sd3_1
Xhold114 _275_/A0 _609_/Q VPWR VGND sg13g2_dlygate4sd3_1
Xhold103 _657_/D _461_/Q VPWR VGND sg13g2_dlygate4sd3_1
XFILLER_35_791 VPWR VGND sg13g2_decap_8
XFILLER_2_813 VPWR VGND sg13g2_decap_8
XFILLER_6_607 VPWR VGND sg13g2_decap_8
Xclkbuf_5_5__f_clk_regs _577_/CLK clkbuf_4_2_0_clk_regs/X VPWR VGND sg13g2_buf_16
XFILLER_49_349 VPWR VGND sg13g2_decap_8
XFILLER_14_931 VPWR VGND sg13g2_decap_8
XFILLER_26_791 VPWR VGND sg13g2_decap_8
X_603_ _603_/Q _618_/CLK _603_/D fanout76/X VPWR VGND sg13g2_dfrbpq_1
X_534_ _534_/Q _534_/CLK _534_/D fanout91/X VPWR VGND sg13g2_dfrbpq_1
X_465_ _465_/Q _441_/Y _465_/D fanout78/X VPWR VGND sg13g2_dfrbpq_1
XFILLER_14_975 VPWR VGND sg13g2_fill_2
XFILLER_41_750 VPWR VGND sg13g2_decap_8
X_396_ _561_/D _560_/Q _561_/Q _397_/S VPWR VGND sg13g2_mux2_1
XFILLER_5_673 VPWR VGND sg13g2_decap_8
XFILLER_49_850 VPWR VGND sg13g2_decap_8
XFILLER_48_360 VPWR VGND sg13g2_decap_8
XFILLER_17_791 VPWR VGND sg13g2_decap_8
XFILLER_47_809 VPWR VGND sg13g2_decap_8
XFILLER_46_308 VPWR VGND sg13g2_decap_8
XFILLER_11_945 VPWR VGND sg13g2_decap_8
Xfanout42 _374_/S _376_/S VPWR VGND sg13g2_buf_1
Xfanout53 _331_/S _321_/S VPWR VGND sg13g2_buf_1
Xfanout64 _254_/B _255_/B VPWR VGND sg13g2_buf_1
Xfanout75 fanout75/X fanout93/X VPWR VGND sg13g2_buf_1
Xfanout86 fanout86/X fanout87/X VPWR VGND sg13g2_buf_1
Xfanout97 fanout97/X fanout98/X VPWR VGND sg13g2_buf_1
X_250_ _250_/X _631_/Q _252_/B VPWR VGND sg13g2_and2_1
XFILLER_7_905 VPWR VGND sg13g2_decap_8
XFILLER_2_610 VPWR VGND sg13g2_decap_8
XFILLER_2_687 VPWR VGND sg13g2_decap_8
XFILLER_46_831 VPWR VGND sg13g2_decap_8
XFILLER_45_374 VPWR VGND sg13g2_decap_8
X_517_ _517_/Q _618_/CLK _517_/D fanout76/X VPWR VGND sg13g2_dfrbpq_1
X_448_ _448_/Y _459_/A _459_/B VPWR VGND sg13g2_xnor2_1
Xclkload12 clkload12/Y _616_/CLK VPWR VGND sg13g2_inv_1
X_379_ _544_/D _543_/Q _544_/Q _405_/S VPWR VGND sg13g2_mux2_1
XFILLER_6_982 VPWR VGND sg13g2_decap_8
XFILLER_47_1018 VPWR VGND sg13g2_decap_8
Xclkload6 clkload6/Y _660_/CLK VPWR VGND sg13g2_inv_1
XFILLER_47_606 VPWR VGND sg13g2_decap_8
XFILLER_43_812 VPWR VGND sg13g2_decap_8
X_302_ _471_/D _471_/Q _302_/B VPWR VGND sg13g2_xnor2_1
X_233_ _464_/D _233_/A0 _464_/Q _236_/S VPWR VGND sg13g2_mux2_1
XFILLER_7_779 VPWR VGND sg13g2_decap_8
XFILLER_7_702 VPWR VGND sg13g2_decap_8
XFILLER_2_484 VPWR VGND sg13g2_decap_8
XFILLER_3_941 VPWR VGND sg13g2_decap_8
XFILLER_25_812 VPWR VGND sg13g2_decap_8
XFILLER_40_826 VPWR VGND sg13g2_decap_8
XFILLER_0_911 VPWR VGND sg13g2_decap_8
XFILLER_3_259 VPWR VGND sg13g2_fill_1
XFILLER_0_988 VPWR VGND sg13g2_decap_8
XFILLER_16_812 VPWR VGND sg13g2_decap_8
XFILLER_47_458 VPWR VGND sg13g2_decap_8
XFILLER_43_686 VPWR VGND sg13g2_decap_8
XFILLER_7_576 VPWR VGND sg13g2_decap_8
XFILLER_22_848 VPWR VGND sg13g2_decap_4
Xoutput19 uio_oe[5] _254_/X VPWR VGND sg13g2_buf_1
XFILLER_13_804 VPWR VGND sg13g2_decap_8
Xclkbuf_5_20__f_clk_regs _628_/CLK clkbuf_4_10_0_clk_regs/X VPWR VGND sg13g2_buf_16
XFILLER_4_557 VPWR VGND sg13g2_decap_8
XFILLER_0_785 VPWR VGND sg13g2_decap_8
XFILLER_48_723 VPWR VGND sg13g2_decap_8
XFILLER_47_244 VPWR VGND sg13g2_fill_1
XFILLER_46_71 VPWR VGND sg13g2_fill_1
XFILLER_12_881 VPWR VGND sg13g2_decap_8
XFILLER_8_874 VPWR VGND sg13g2_decap_8
XFILLER_7_43 VPWR VGND sg13g2_fill_2
XFILLER_7_32 VPWR VGND sg13g2_fill_1
XFILLER_39_756 VPWR VGND sg13g2_decap_8
XFILLER_1_549 VPWR VGND sg13g2_decap_8
Xclkbuf_5_4__f_clk_regs _659_/CLK clkbuf_4_2_0_clk_regs/X VPWR VGND sg13g2_buf_16
XFILLER_44_225 VPWR VGND sg13g2_fill_2
XFILLER_45_715 VPWR VGND sg13g2_decap_8
X_550_ _550_/Q _563_/CLK _550_/D fanout95/X VPWR VGND sg13g2_dfrbpq_1
X_481_ _481_/Q _570_/CLK _481_/D fanout91/X VPWR VGND sg13g2_dfrbpq_1
XFILLER_5_855 VPWR VGND sg13g2_decap_8
XFILLER_0_582 VPWR VGND sg13g2_decap_8
XFILLER_48_542 VPWR VGND sg13g2_decap_8
XFILLER_17_973 VPWR VGND sg13g2_decap_8
Xhold126 _610_/D _583_/Q VPWR VGND sg13g2_dlygate4sd3_1
Xhold115 _631_/D _275_/X VPWR VGND sg13g2_dlygate4sd3_1
Xhold104 hold104/X _646_/Q VPWR VGND sg13g2_dlygate4sd3_1
Xhold137 _606_/D _579_/Q VPWR VGND sg13g2_dlygate4sd3_1
XFILLER_35_770 VPWR VGND sg13g2_decap_8
XFILLER_2_869 VPWR VGND sg13g2_decap_8
X_602_ _602_/Q _659_/CLK _602_/D fanout81/X VPWR VGND sg13g2_dfrbpq_1
XFILLER_49_328 VPWR VGND sg13g2_decap_8
XFILLER_14_910 VPWR VGND sg13g2_decap_8
XFILLER_26_770 VPWR VGND sg13g2_decap_8
XFILLER_45_589 VPWR VGND sg13g2_decap_8
X_533_ _533_/Q _534_/CLK _533_/D fanout83/X VPWR VGND sg13g2_dfrbpq_1
X_464_ _464_/Q _440_/Y _464_/D fanout79/X VPWR VGND sg13g2_dfrbpq_1
XFILLER_14_987 VPWR VGND sg13g2_decap_8
X_395_ _560_/D _559_/Q _560_/Q _398_/S VPWR VGND sg13g2_mux2_1
XFILLER_5_652 VPWR VGND sg13g2_decap_8
XFILLER_17_1026 VPWR VGND sg13g2_fill_2
XFILLER_17_770 VPWR VGND sg13g2_decap_8
XFILLER_32_784 VPWR VGND sg13g2_decap_8
XFILLER_9_991 VPWR VGND sg13g2_decap_8
XFILLER_11_924 VPWR VGND sg13g2_decap_8
Xfanout43 _376_/S fanout46/X VPWR VGND sg13g2_buf_1
Xfanout54 _323_/S _321_/S VPWR VGND sg13g2_buf_1
Xfanout65 fanout65/X fanout66/X VPWR VGND sg13g2_buf_1
Xfanout76 fanout76/X fanout84/X VPWR VGND sg13g2_buf_1
Xfanout87 fanout87/X fanout90/X VPWR VGND sg13g2_buf_1
Xfanout98 fanout98/X input1/X VPWR VGND sg13g2_buf_1
XFILLER_2_666 VPWR VGND sg13g2_decap_8
XFILLER_45_320 VPWR VGND sg13g2_decap_8
XFILLER_45_353 VPWR VGND sg13g2_decap_8
XFILLER_46_810 VPWR VGND sg13g2_decap_8
XFILLER_14_784 VPWR VGND sg13g2_decap_8
X_516_ _516_/Q _656_/CLK _516_/D fanout76/X VPWR VGND sg13g2_dfrbpq_1
X_447_ _447_/Y _459_/A _459_/B VPWR VGND sg13g2_xnor2_1
X_378_ _543_/D _542_/Q _543_/Q _405_/S VPWR VGND sg13g2_mux2_1
Xclkload13 clkload13/Y _623_/CLK VPWR VGND sg13g2_inv_1
XFILLER_6_961 VPWR VGND sg13g2_decap_8
XFILLER_20_798 VPWR VGND sg13g2_decap_8
Xclkload7 clkload7/Y _511_/CLK VPWR VGND sg13g2_inv_1
X_301_ _301_/Y _469_/Q _470_/Q _471_/Q _311_/S VPWR VGND sg13g2_nand4_1
X_232_ _236_/S _647_/Q _648_/Q VPWR VGND sg13g2_nand2b_1
XFILLER_11_798 VPWR VGND sg13g2_decap_8
XFILLER_3_920 VPWR VGND sg13g2_decap_8
XFILLER_7_758 VPWR VGND sg13g2_decap_8
XFILLER_2_463 VPWR VGND sg13g2_decap_8
XFILLER_3_997 VPWR VGND sg13g2_decap_8
XFILLER_45_161 VPWR VGND sg13g2_fill_2
XFILLER_46_684 VPWR VGND sg13g2_decap_8
XFILLER_40_805 VPWR VGND sg13g2_decap_8
XFILLER_4_739 VPWR VGND sg13g2_decap_8
XFILLER_0_967 VPWR VGND sg13g2_decap_8
XFILLER_48_905 VPWR VGND sg13g2_decap_8
XFILLER_47_437 VPWR VGND sg13g2_decap_8
XFILLER_31_805 VPWR VGND sg13g2_fill_2
XFILLER_43_665 VPWR VGND sg13g2_decap_8
XFILLER_7_555 VPWR VGND sg13g2_decap_8
XFILLER_3_794 VPWR VGND sg13g2_decap_8
XFILLER_47_960 VPWR VGND sg13g2_fill_2
XFILLER_22_827 VPWR VGND sg13g2_decap_8
Xclkbuf_5_3__f_clk_regs _657_/CLK clkbuf_4_1_0_clk_regs/X VPWR VGND sg13g2_buf_16
XFILLER_5_1027 VPWR VGND sg13g2_fill_2
XFILLER_5_1016 VPWR VGND sg13g2_decap_8
XFILLER_9_809 VPWR VGND sg13g2_decap_8
XFILLER_4_536 VPWR VGND sg13g2_decap_8
XFILLER_0_764 VPWR VGND sg13g2_decap_8
XFILLER_48_779 VPWR VGND sg13g2_decap_8
XFILLER_48_702 VPWR VGND sg13g2_decap_8
XFILLER_47_212 VPWR VGND sg13g2_fill_2
XFILLER_12_860 VPWR VGND sg13g2_decap_8
XFILLER_8_853 VPWR VGND sg13g2_decap_8
XFILLER_3_591 VPWR VGND sg13g2_decap_8
XFILLER_10_819 VPWR VGND sg13g2_decap_8
XFILLER_1_528 VPWR VGND sg13g2_decap_8
X_480_ _480_/Q _505_/CLK _480_/D fanout91/X VPWR VGND sg13g2_dfrbpq_1
XFILLER_5_834 VPWR VGND sg13g2_decap_8
XFILLER_0_561 VPWR VGND sg13g2_decap_8
XFILLER_36_749 VPWR VGND sg13g2_decap_8
XFILLER_48_598 VPWR VGND sg13g2_decap_8
XFILLER_48_521 VPWR VGND sg13g2_decap_8
Xhold138 _273_/A0 _615_/Q VPWR VGND sg13g2_dlygate4sd3_1
Xhold127 _615_/D _588_/Q VPWR VGND sg13g2_dlygate4sd3_1
Xhold116 _605_/D _578_/Q VPWR VGND sg13g2_dlygate4sd3_1
Xhold105 _660_/D _464_/Q VPWR VGND sg13g2_dlygate4sd3_1
XFILLER_27_749 VPWR VGND sg13g2_decap_8
XFILLER_42_719 VPWR VGND sg13g2_decap_8
XFILLER_2_848 VPWR VGND sg13g2_decap_8
XFILLER_18_749 VPWR VGND sg13g2_decap_8
XFILLER_45_524 VPWR VGND sg13g2_fill_2
X_601_ _601_/Q _628_/CLK _601_/D fanout68/X VPWR VGND sg13g2_dfrbpq_1
XFILLER_49_307 VPWR VGND sg13g2_decap_8
XFILLER_41_785 VPWR VGND sg13g2_decap_8
XFILLER_45_568 VPWR VGND sg13g2_decap_8
X_532_ _532_/Q _535_/CLK _532_/D fanout83/X VPWR VGND sg13g2_dfrbpq_1
X_463_ _463_/Q _439_/Y _463_/D fanout79/X VPWR VGND sg13g2_dfrbpq_1
X_394_ _559_/D _558_/Q _559_/Q _397_/S VPWR VGND sg13g2_mux2_1
Xclkbuf_4_6_0_clk_regs clkbuf_4_6_0_clk_regs/X clkbuf_0_clk_regs/X VPWR VGND sg13g2_buf_8
XFILLER_5_631 VPWR VGND sg13g2_decap_8
XFILLER_0_380 VPWR VGND sg13g2_decap_8
XFILLER_1_892 VPWR VGND sg13g2_decap_8
XFILLER_49_885 VPWR VGND sg13g2_decap_8
XFILLER_48_395 VPWR VGND sg13g2_decap_8
XFILLER_32_763 VPWR VGND sg13g2_decap_8
XFILLER_44_590 VPWR VGND sg13g2_decap_8
XFILLER_9_970 VPWR VGND sg13g2_decap_8
XFILLER_11_903 VPWR VGND sg13g2_decap_8
XFILLER_23_763 VPWR VGND sg13g2_decap_8
XFILLER_23_774 VPWR VGND sg13g2_fill_1
Xfanout44 _429_/S fanout46/X VPWR VGND sg13g2_buf_1
Xfanout55 _321_/S fanout61/X VPWR VGND sg13g2_buf_1
Xfanout66 fanout66/X fanout72/X VPWR VGND sg13g2_buf_1
Xfanout77 fanout77/X fanout84/X VPWR VGND sg13g2_buf_1
Xfanout88 fanout88/X fanout89/X VPWR VGND sg13g2_buf_1
XFILLER_2_645 VPWR VGND sg13g2_decap_8
X_515_ _515_/Q _515_/CLK _515_/D fanout89/X VPWR VGND sg13g2_dfrbpq_1
XFILLER_14_763 VPWR VGND sg13g2_decap_8
X_446_ _446_/Y _459_/A _449_/B VPWR VGND sg13g2_xnor2_1
X_377_ _542_/D _541_/Q _542_/Q _398_/S VPWR VGND sg13g2_mux2_1
XFILLER_10_980 VPWR VGND sg13g2_decap_8
Xclkload14 clkload14/Y _513_/CLK VPWR VGND sg13g2_inv_1
XFILLER_6_940 VPWR VGND sg13g2_decap_8
XFILLER_5_483 VPWR VGND sg13g2_decap_8
XFILLER_49_682 VPWR VGND sg13g2_decap_8
XFILLER_20_777 VPWR VGND sg13g2_decap_8
Xclkload8 clkload8/Y _534_/CLK VPWR VGND sg13g2_inv_1
XFILLER_43_847 VPWR VGND sg13g2_decap_4
X_300_ _470_/D _302_/B _300_/B VPWR VGND sg13g2_and2_1
X_231_ _465_/D _236_/A0 _465_/Q _231_/S VPWR VGND sg13g2_mux2_1
XFILLER_11_777 VPWR VGND sg13g2_decap_8
XFILLER_7_737 VPWR VGND sg13g2_decap_8
XFILLER_6_0 VPWR VGND sg13g2_fill_1
XFILLER_3_976 VPWR VGND sg13g2_decap_8
XFILLER_34_814 VPWR VGND sg13g2_fill_1
XFILLER_46_663 VPWR VGND sg13g2_decap_8
X_429_ _594_/D _593_/Q _594_/Q _429_/S VPWR VGND sg13g2_mux2_1
Xclkbuf_5_2__f_clk_regs _618_/CLK clkbuf_4_1_0_clk_regs/X VPWR VGND sg13g2_buf_16
Xinput1 input1/X rst_n VPWR VGND sg13g2_buf_1
XFILLER_25_847 VPWR VGND sg13g2_decap_4
XFILLER_10_22 VPWR VGND sg13g2_fill_2
XFILLER_4_718 VPWR VGND sg13g2_decap_8
XFILLER_0_946 VPWR VGND sg13g2_decap_8
XFILLER_47_416 VPWR VGND sg13g2_decap_8
XFILLER_16_847 VPWR VGND sg13g2_decap_8
XFILLER_43_644 VPWR VGND sg13g2_decap_8
XFILLER_7_534 VPWR VGND sg13g2_decap_8
XFILLER_3_773 VPWR VGND sg13g2_decap_8
XFILLER_47_983 VPWR VGND sg13g2_fill_1
XFILLER_47_972 VPWR VGND sg13g2_fill_1
XFILLER_22_806 VPWR VGND sg13g2_decap_8
XFILLER_30_850 VPWR VGND sg13g2_fill_2
XFILLER_44_419 VPWR VGND sg13g2_decap_8
XFILLER_13_839 VPWR VGND sg13g2_decap_8
Xdelaybuf_2_clk delaybuf_3_clk/A _256_/B VPWR VGND sg13g2_buf_16
XFILLER_4_515 VPWR VGND sg13g2_decap_8
XFILLER_0_743 VPWR VGND sg13g2_decap_8
XFILLER_48_758 VPWR VGND sg13g2_decap_8
XFILLER_43_463 VPWR VGND sg13g2_decap_8
XFILLER_8_832 VPWR VGND sg13g2_decap_8
XFILLER_7_45 VPWR VGND sg13g2_fill_1
XFILLER_7_386 VPWR VGND sg13g2_fill_2
XFILLER_7_331 VPWR VGND sg13g2_decap_8
XFILLER_3_570 VPWR VGND sg13g2_decap_8
XFILLER_1_507 VPWR VGND sg13g2_decap_8
XFILLER_16_65 VPWR VGND sg13g2_fill_2
XFILLER_38_791 VPWR VGND sg13g2_decap_8
XFILLER_10_1022 VPWR VGND sg13g2_decap_8
XFILLER_5_813 VPWR VGND sg13g2_decap_8
XFILLER_0_540 VPWR VGND sg13g2_decap_8
XFILLER_48_500 VPWR VGND sg13g2_decap_8
XFILLER_29_791 VPWR VGND sg13g2_decap_8
XFILLER_48_577 VPWR VGND sg13g2_decap_8
XFILLER_44_772 VPWR VGND sg13g2_decap_8
XFILLER_44_794 VPWR VGND sg13g2_decap_8
Xhold139 _612_/D _585_/Q VPWR VGND sg13g2_dlygate4sd3_1
Xhold128 _619_/D _590_/Q VPWR VGND sg13g2_dlygate4sd3_1
Xhold117 _274_/A0 _616_/Q VPWR VGND sg13g2_dlygate4sd3_1
Xhold106 _650_/D _658_/Q VPWR VGND sg13g2_dlygate4sd3_1
XFILLER_21_0 VPWR VGND sg13g2_fill_1
XFILLER_2_1009 VPWR VGND sg13g2_decap_8
XFILLER_2_827 VPWR VGND sg13g2_decap_8
X_600_ _600_/Q _630_/CLK _600_/D fanout65/X VPWR VGND sg13g2_dfrbpq_1
X_531_ _531_/Q _658_/CLK _531_/D fanout81/X VPWR VGND sg13g2_dfrbpq_1
XFILLER_14_945 VPWR VGND sg13g2_decap_8
XFILLER_14_956 VPWR VGND sg13g2_fill_2
XFILLER_41_764 VPWR VGND sg13g2_decap_8
X_462_ _658_/D _438_/Y _462_/D fanout79/X VPWR VGND sg13g2_dfrbpq_1
X_393_ _558_/D _557_/Q _558_/Q _397_/S VPWR VGND sg13g2_mux2_1
XFILLER_5_687 VPWR VGND sg13g2_decap_8
XFILLER_5_610 VPWR VGND sg13g2_decap_8
XFILLER_4_131 VPWR VGND sg13g2_fill_1
XFILLER_1_871 VPWR VGND sg13g2_decap_8
XFILLER_49_864 VPWR VGND sg13g2_decap_8
XFILLER_48_374 VPWR VGND sg13g2_decap_8
XFILLER_17_1028 VPWR VGND sg13g2_fill_1
XFILLER_11_959 VPWR VGND sg13g2_decap_8
Xfanout45 _428_/S fanout46/X VPWR VGND sg13g2_buf_1
Xfanout56 _397_/S _398_/S VPWR VGND sg13g2_buf_1
Xfanout67 fanout67/X fanout72/X VPWR VGND sg13g2_buf_1
Xfanout78 fanout78/X fanout80/X VPWR VGND sg13g2_buf_1
Xfanout89 fanout89/X fanout90/X VPWR VGND sg13g2_buf_1
XFILLER_2_624 VPWR VGND sg13g2_decap_8
XFILLER_7_919 VPWR VGND sg13g2_decap_8
XFILLER_45_388 VPWR VGND sg13g2_decap_8
X_514_ _514_/Q _515_/CLK _514_/D fanout88/X VPWR VGND sg13g2_dfrbpq_1
XFILLER_46_845 VPWR VGND sg13g2_decap_8
XFILLER_41_583 VPWR VGND sg13g2_decap_4
Xclkload15 clkload15/Y _620_/CLK VPWR VGND sg13g2_inv_1
X_445_ _445_/Y _456_/A _452_/B VPWR VGND sg13g2_xnor2_1
X_376_ _541_/D _540_/Q _541_/Q _376_/S VPWR VGND sg13g2_mux2_1
Xclkbuf_5_1__f_clk_regs _541_/CLK clkbuf_4_0_0_clk_regs/X VPWR VGND sg13g2_buf_16
XFILLER_6_996 VPWR VGND sg13g2_decap_8
XFILLER_37_812 VPWR VGND sg13g2_decap_8
XFILLER_37_823 VPWR VGND sg13g2_fill_2
XFILLER_49_661 VPWR VGND sg13g2_decap_8
XFILLER_20_756 VPWR VGND sg13g2_decap_8
Xclkload9 clkload9/Y _567_/CLK VPWR VGND sg13g2_inv_1
XFILLER_28_812 VPWR VGND sg13g2_decap_8
XFILLER_28_823 VPWR VGND sg13g2_fill_2
XFILLER_42_303 VPWR VGND sg13g2_fill_2
XFILLER_43_826 VPWR VGND sg13g2_decap_8
XFILLER_11_756 VPWR VGND sg13g2_decap_8
Xclkbuf_1_1__f__017__regs _461_/CLK clkbuf_0__017__regs/X VPWR VGND sg13g2_buf_16
X_230_ _466_/D _235_/A0 _654_/D _231_/S VPWR VGND sg13g2_mux2_1
XFILLER_7_716 VPWR VGND sg13g2_decap_8
XFILLER_2_410 VPWR VGND sg13g2_fill_2
XFILLER_3_955 VPWR VGND sg13g2_decap_8
XFILLER_19_812 VPWR VGND sg13g2_decap_8
XFILLER_19_823 VPWR VGND sg13g2_fill_2
XFILLER_2_498 VPWR VGND sg13g2_decap_8
XFILLER_46_642 VPWR VGND sg13g2_decap_8
X_428_ _593_/D _592_/Q _593_/Q _428_/S VPWR VGND sg13g2_mux2_1
X_359_ _524_/D _523_/Q _524_/Q _374_/S VPWR VGND sg13g2_mux2_1
XFILLER_6_793 VPWR VGND sg13g2_decap_8
XFILLER_25_826 VPWR VGND sg13g2_decap_8
Xinput2 _291_/B ui_in[0] VPWR VGND sg13g2_buf_1
XFILLER_3_229 VPWR VGND sg13g2_fill_1
XFILLER_0_925 VPWR VGND sg13g2_decap_8
XFILLER_16_826 VPWR VGND sg13g2_decap_8
XFILLER_43_623 VPWR VGND sg13g2_decap_8
XFILLER_7_513 VPWR VGND sg13g2_decap_8
XFILLER_2_295 VPWR VGND sg13g2_fill_1
XFILLER_3_752 VPWR VGND sg13g2_decap_8
XFILLER_46_483 VPWR VGND sg13g2_decap_8
XFILLER_13_818 VPWR VGND sg13g2_decap_8
XFILLER_0_722 VPWR VGND sg13g2_decap_8
XFILLER_0_799 VPWR VGND sg13g2_decap_8
XFILLER_48_737 VPWR VGND sg13g2_decap_8
XFILLER_43_420 VPWR VGND sg13g2_decap_8
XFILLER_8_811 VPWR VGND sg13g2_decap_8
XFILLER_12_895 VPWR VGND sg13g2_decap_8
XFILLER_8_888 VPWR VGND sg13g2_decap_8
XFILLER_7_310 VPWR VGND sg13g2_decap_8
XFILLER_46_280 VPWR VGND sg13g2_decap_8
XFILLER_47_781 VPWR VGND sg13g2_decap_8
XFILLER_38_770 VPWR VGND sg13g2_decap_8
XFILLER_45_729 VPWR VGND sg13g2_decap_8
XFILLER_10_1001 VPWR VGND sg13g2_decap_8
XFILLER_5_869 VPWR VGND sg13g2_decap_8
XFILLER_0_596 VPWR VGND sg13g2_decap_8
XFILLER_17_943 VPWR VGND sg13g2_fill_2
XFILLER_29_770 VPWR VGND sg13g2_decap_8
XFILLER_43_261 VPWR VGND sg13g2_fill_1
XFILLER_44_751 VPWR VGND sg13g2_decap_8
XFILLER_48_556 VPWR VGND sg13g2_decap_8
Xhold129 _623_/D _594_/Q VPWR VGND sg13g2_dlygate4sd3_1
Xhold118 _638_/D _274_/X VPWR VGND sg13g2_dlygate4sd3_1
Xhold107 _651_/D _659_/Q VPWR VGND sg13g2_dlygate4sd3_1
XFILLER_14_0 VPWR VGND sg13g2_fill_1
XFILLER_35_784 VPWR VGND sg13g2_decap_8
XFILLER_2_806 VPWR VGND sg13g2_decap_8
XFILLER_1_327 VPWR VGND sg13g2_fill_1
XFILLER_14_924 VPWR VGND sg13g2_decap_8
XFILLER_26_784 VPWR VGND sg13g2_decap_8
X_530_ _530_/Q _618_/CLK _530_/D fanout76/X VPWR VGND sg13g2_dfrbpq_1
X_461_ _461_/Q _461_/CLK _461_/D fanout78/X VPWR VGND sg13g2_dfrbpq_1
XFILLER_14_968 VPWR VGND sg13g2_decap_8
XFILLER_41_743 VPWR VGND sg13g2_decap_8
X_392_ _557_/D _556_/Q _557_/Q _392_/S VPWR VGND sg13g2_mux2_1
Xclkbuf_5_0__f_clk_regs _656_/CLK clkbuf_4_0_0_clk_regs/X VPWR VGND sg13g2_buf_16
XFILLER_5_666 VPWR VGND sg13g2_decap_8
XFILLER_1_850 VPWR VGND sg13g2_decap_8
XFILLER_49_843 VPWR VGND sg13g2_decap_8
XFILLER_48_353 VPWR VGND sg13g2_decap_8
XFILLER_17_784 VPWR VGND sg13g2_decap_8
X_659_ _659_/Q _659_/CLK _659_/D fanout80/X VPWR VGND sg13g2_dfrbpq_1
XFILLER_32_798 VPWR VGND sg13g2_fill_2
XFILLER_11_938 VPWR VGND sg13g2_decap_8
Xfanout46 fanout46/X fanout61/X VPWR VGND sg13g2_buf_1
Xfanout57 _398_/S _392_/S VPWR VGND sg13g2_buf_1
Xfanout68 fanout68/X fanout69/X VPWR VGND sg13g2_buf_1
Xfanout79 fanout79/X fanout80/X VPWR VGND sg13g2_buf_1
XFILLER_2_603 VPWR VGND sg13g2_decap_8
XFILLER_46_824 VPWR VGND sg13g2_decap_8
XFILLER_45_367 VPWR VGND sg13g2_decap_8
X_513_ _513_/Q _513_/CLK _513_/D fanout88/X VPWR VGND sg13g2_dfrbpq_1
X_444_ _444_/Y _444_/A _444_/B VPWR VGND sg13g2_xnor2_1
XFILLER_14_798 VPWR VGND sg13g2_decap_8
Xclkload16 clkload16/Y _563_/CLK VPWR VGND sg13g2_inv_1
X_375_ _540_/D _539_/Q _540_/Q _376_/S VPWR VGND sg13g2_mux2_1
XFILLER_6_975 VPWR VGND sg13g2_decap_8
XFILLER_49_640 VPWR VGND sg13g2_decap_8
XFILLER_2_477 VPWR VGND sg13g2_decap_8
XFILLER_3_934 VPWR VGND sg13g2_decap_8
XFILLER_46_621 VPWR VGND sg13g2_decap_8
X_427_ _592_/D _591_/Q _592_/Q _428_/S VPWR VGND sg13g2_mux2_1
X_358_ _523_/D _522_/Q _523_/Q _374_/S VPWR VGND sg13g2_mux2_1
XFILLER_46_698 VPWR VGND sg13g2_decap_8
X_289_ _289_/Y _226_/Y _258_/A _288_/Y VPWR VGND sg13g2_o21ai_1
XFILLER_6_772 VPWR VGND sg13g2_decap_8
Xdelaybuf_21_clk delaybuf_22_clk/A delaybuf_21_clk/A VPWR VGND sg13g2_buf_16
XFILLER_25_805 VPWR VGND sg13g2_decap_8
XFILLER_40_819 VPWR VGND sg13g2_decap_8
Xinput3 input3/X ui_in[1] VPWR VGND sg13g2_buf_1
XFILLER_0_904 VPWR VGND sg13g2_decap_8
XFILLER_10_24 VPWR VGND sg13g2_fill_1
XFILLER_16_805 VPWR VGND sg13g2_decap_8
Xdelaybuf_12_clk delaybuf_13_clk/A delaybuf_12_clk/A VPWR VGND sg13g2_buf_16
XFILLER_48_919 VPWR VGND sg13g2_fill_2
XFILLER_43_679 VPWR VGND sg13g2_decap_8
XFILLER_13_1021 VPWR VGND sg13g2_decap_8
XFILLER_3_731 VPWR VGND sg13g2_decap_8
XFILLER_7_569 VPWR VGND sg13g2_decap_8
XFILLER_46_462 VPWR VGND sg13g2_decap_8
XFILLER_15_882 VPWR VGND sg13g2_decap_8
Xclkbuf_1_0__f__017_ _258_/B clkbuf_0__017_/X VPWR VGND sg13g2_buf_16
XFILLER_0_701 VPWR VGND sg13g2_decap_8
XFILLER_0_778 VPWR VGND sg13g2_decap_8
XFILLER_48_716 VPWR VGND sg13g2_decap_8
XFILLER_46_97 VPWR VGND sg13g2_fill_1
XFILLER_12_874 VPWR VGND sg13g2_decap_8
XFILLER_8_867 VPWR VGND sg13g2_decap_8
XFILLER_39_749 VPWR VGND sg13g2_decap_8
XFILLER_47_760 VPWR VGND sg13g2_decap_8
XFILLER_45_708 VPWR VGND sg13g2_decap_8
XFILLER_16_67 VPWR VGND sg13g2_fill_1
XFILLER_5_848 VPWR VGND sg13g2_decap_8
XFILLER_4_369 VPWR VGND sg13g2_fill_2
XFILLER_0_575 VPWR VGND sg13g2_decap_8
XFILLER_48_535 VPWR VGND sg13g2_decap_8
XFILLER_44_730 VPWR VGND sg13g2_decap_8
Xhold108 _649_/D _657_/Q VPWR VGND sg13g2_dlygate4sd3_1
Xhold119 _607_/D _580_/Q VPWR VGND sg13g2_dlygate4sd3_1
XFILLER_35_763 VPWR VGND sg13g2_decap_8
XFILLER_14_903 VPWR VGND sg13g2_decap_8
XFILLER_26_763 VPWR VGND sg13g2_decap_8
XFILLER_41_722 VPWR VGND sg13g2_decap_8
X_460_ _460_/Y _460_/A _460_/B VPWR VGND sg13g2_xnor2_1
X_391_ _556_/D _555_/Q _556_/Q _405_/S VPWR VGND sg13g2_mux2_1
XFILLER_41_799 VPWR VGND sg13g2_decap_8
XFILLER_5_645 VPWR VGND sg13g2_decap_8
XFILLER_0_361 VPWR VGND sg13g2_decap_8
XFILLER_1_1011 VPWR VGND sg13g2_decap_8
XFILLER_49_899 VPWR VGND sg13g2_decap_8
XFILLER_49_822 VPWR VGND sg13g2_decap_8
XFILLER_48_332 VPWR VGND sg13g2_decap_8
XFILLER_17_1019 VPWR VGND sg13g2_decap_8
XFILLER_17_763 VPWR VGND sg13g2_decap_8
XFILLER_32_777 VPWR VGND sg13g2_decap_8
X_589_ _616_/D _616_/CLK _589_/D fanout68/X VPWR VGND sg13g2_dfrbpq_1
X_658_ _658_/Q _658_/CLK _658_/D fanout79/X VPWR VGND sg13g2_dfrbpq_1
XFILLER_9_984 VPWR VGND sg13g2_decap_8
XFILLER_11_917 VPWR VGND sg13g2_decap_8
Xfanout47 _412_/S _366_/S VPWR VGND sg13g2_buf_1
Xfanout58 _404_/S _405_/S VPWR VGND sg13g2_buf_1
Xfanout69 fanout69/X fanout72/X VPWR VGND sg13g2_buf_1
XFILLER_2_659 VPWR VGND sg13g2_decap_8
XFILLER_45_313 VPWR VGND sg13g2_decap_8
XFILLER_46_803 VPWR VGND sg13g2_decap_8
XFILLER_14_777 VPWR VGND sg13g2_decap_8
XFILLER_45_346 VPWR VGND sg13g2_decap_8
X_512_ _512_/Q _621_/CLK _512_/D fanout88/X VPWR VGND sg13g2_dfrbpq_1
X_443_ _443_/Y _460_/A _444_/B VPWR VGND sg13g2_xnor2_1
X_374_ _539_/D _538_/Q _539_/Q _374_/S VPWR VGND sg13g2_mux2_1
XFILLER_10_994 VPWR VGND sg13g2_decap_8
Xclkload17 clkload17/Y _461_/CLK VPWR VGND sg13g2_inv_1
XFILLER_6_954 VPWR VGND sg13g2_decap_8
Xclkbuf_leaf_0_clk _459_/B delaybuf_16_clk/X VPWR VGND sg13g2_buf_8
XFILLER_49_696 VPWR VGND sg13g2_decap_8
XFILLER_9_781 VPWR VGND sg13g2_decap_8
Xclkbuf_4_5_0_clk_regs clkbuf_4_5_0_clk_regs/X clkbuf_0_clk_regs/X VPWR VGND sg13g2_buf_8
XFILLER_3_913 VPWR VGND sg13g2_decap_8
XFILLER_2_456 VPWR VGND sg13g2_decap_8
XFILLER_46_677 VPWR VGND sg13g2_decap_8
XFILLER_46_600 VPWR VGND sg13g2_decap_8
X_426_ _591_/D _590_/Q _591_/Q _428_/S VPWR VGND sg13g2_mux2_1
X_357_ _522_/D _521_/Q _522_/Q _412_/S VPWR VGND sg13g2_mux2_1
XFILLER_10_791 VPWR VGND sg13g2_decap_8
X_288_ _288_/Y _288_/A1 _279_/Y _281_/Y _288_/B2 VPWR VGND sg13g2_a22oi_1
XFILLER_6_751 VPWR VGND sg13g2_decap_8
Xinput4 _281_/A ui_in[2] VPWR VGND sg13g2_buf_1
XFILLER_49_482 VPWR VGND sg13g2_decap_8
XFILLER_13_1000 VPWR VGND sg13g2_decap_8
XFILLER_43_658 VPWR VGND sg13g2_decap_8
XFILLER_3_710 VPWR VGND sg13g2_decap_8
Xdelaybuf_5_clk delaybuf_6_clk/A delaybuf_5_clk/A VPWR VGND sg13g2_buf_16
XFILLER_7_548 VPWR VGND sg13g2_decap_8
XFILLER_4_0 VPWR VGND sg13g2_fill_1
XFILLER_3_787 VPWR VGND sg13g2_decap_8
XFILLER_15_861 VPWR VGND sg13g2_decap_8
XFILLER_47_953 VPWR VGND sg13g2_decap_8
XFILLER_46_441 VPWR VGND sg13g2_decap_8
X_409_ _574_/D _573_/Q _574_/Q _412_/S VPWR VGND sg13g2_mux2_1
XFILLER_5_1009 VPWR VGND sg13g2_decap_8
XFILLER_4_529 VPWR VGND sg13g2_decap_8
XFILLER_0_757 VPWR VGND sg13g2_decap_8
XFILLER_12_853 VPWR VGND sg13g2_decap_8
XFILLER_8_846 VPWR VGND sg13g2_decap_8
XFILLER_7_345 VPWR VGND sg13g2_decap_4
XFILLER_3_584 VPWR VGND sg13g2_decap_8
XFILLER_5_827 VPWR VGND sg13g2_decap_8
XFILLER_0_554 VPWR VGND sg13g2_decap_8
XFILLER_48_514 VPWR VGND sg13g2_decap_8
XFILLER_17_945 VPWR VGND sg13g2_fill_1
XFILLER_44_786 VPWR VGND sg13g2_decap_4
Xhold109 _652_/D _660_/Q VPWR VGND sg13g2_dlygate4sd3_1
XFILLER_4_893 VPWR VGND sg13g2_decap_8
XFILLER_41_701 VPWR VGND sg13g2_decap_8
X_390_ _555_/D _554_/Q _555_/Q _405_/S VPWR VGND sg13g2_mux2_1
XFILLER_41_778 VPWR VGND sg13g2_decap_8
XFILLER_5_624 VPWR VGND sg13g2_decap_8
XFILLER_1_885 VPWR VGND sg13g2_decap_8
XFILLER_49_801 VPWR VGND sg13g2_decap_8
XFILLER_48_311 VPWR VGND sg13g2_decap_8
X_657_ _657_/Q _657_/CLK _657_/D fanout80/X VPWR VGND sg13g2_dfrbpq_1
XFILLER_49_878 VPWR VGND sg13g2_decap_8
XFILLER_48_388 VPWR VGND sg13g2_decap_8
XFILLER_32_756 VPWR VGND sg13g2_decap_8
XFILLER_44_583 VPWR VGND sg13g2_decap_8
X_588_ _588_/Q _628_/CLK _588_/D fanout68/X VPWR VGND sg13g2_dfrbpq_1
XFILLER_9_963 VPWR VGND sg13g2_decap_8
XFILLER_4_690 VPWR VGND sg13g2_decap_8
XFILLER_23_756 VPWR VGND sg13g2_decap_8
Xfanout48 _407_/S _366_/S VPWR VGND sg13g2_buf_1
Xfanout59 _405_/S _392_/S VPWR VGND sg13g2_buf_1
XFILLER_2_638 VPWR VGND sg13g2_decap_8
X_511_ _511_/Q _511_/CLK _511_/D fanout90/X VPWR VGND sg13g2_dfrbpq_1
XFILLER_14_756 VPWR VGND sg13g2_decap_8
X_442_ _442_/Y _460_/A _460_/B VPWR VGND sg13g2_xnor2_1
X_373_ _538_/D _537_/Q _538_/Q _374_/S VPWR VGND sg13g2_mux2_1
XFILLER_10_973 VPWR VGND sg13g2_decap_8
Xclkload18 clkload18/X _460_/A VPWR VGND sg13g2_buf_8
XFILLER_6_933 VPWR VGND sg13g2_decap_8
XFILLER_5_410 VPWR VGND sg13g2_fill_1
XFILLER_1_682 VPWR VGND sg13g2_decap_8
XFILLER_49_675 VPWR VGND sg13g2_decap_8
XFILLER_44_391 VPWR VGND sg13g2_decap_8
XFILLER_3_969 VPWR VGND sg13g2_decap_8
XFILLER_46_656 VPWR VGND sg13g2_decap_8
XFILLER_10_770 VPWR VGND sg13g2_decap_8
X_425_ _590_/D _616_/D _590_/Q _429_/S VPWR VGND sg13g2_mux2_1
X_356_ _521_/D _520_/Q _521_/Q _407_/S VPWR VGND sg13g2_mux2_1
X_287_ _287_/Y _225_/Y _258_/A _286_/Y VPWR VGND sg13g2_o21ai_1
XFILLER_6_730 VPWR VGND sg13g2_decap_8
Xinput5 _279_/B ui_in[3] VPWR VGND sg13g2_buf_1
XFILLER_49_461 VPWR VGND sg13g2_decap_8
XFILLER_33_851 VPWR VGND sg13g2_fill_1
XFILLER_0_939 VPWR VGND sg13g2_decap_8
XFILLER_10_59 VPWR VGND sg13g2_fill_2
XFILLER_47_409 VPWR VGND sg13g2_decap_8
XFILLER_24_840 VPWR VGND sg13g2_decap_8
XFILLER_43_637 VPWR VGND sg13g2_decap_8
XFILLER_24_851 VPWR VGND sg13g2_fill_1
XFILLER_7_527 VPWR VGND sg13g2_decap_8
XFILLER_3_766 VPWR VGND sg13g2_decap_8
XFILLER_46_420 VPWR VGND sg13g2_decap_8
XFILLER_15_840 VPWR VGND sg13g2_decap_8
X_408_ _573_/D _572_/Q _573_/Q _412_/S VPWR VGND sg13g2_mux2_1
X_339_ _504_/D _503_/Q _504_/Q _415_/S VPWR VGND sg13g2_mux2_1
XFILLER_6_593 VPWR VGND sg13g2_decap_8
XFILLER_4_508 VPWR VGND sg13g2_decap_8
XFILLER_0_736 VPWR VGND sg13g2_decap_8
XFILLER_43_456 VPWR VGND sg13g2_decap_8
XFILLER_12_832 VPWR VGND sg13g2_decap_8
XFILLER_8_825 VPWR VGND sg13g2_decap_8
XFILLER_7_324 VPWR VGND sg13g2_decap_8
XFILLER_3_563 VPWR VGND sg13g2_decap_8
XFILLER_46_294 VPWR VGND sg13g2_decap_8
XFILLER_47_795 VPWR VGND sg13g2_decap_8
XFILLER_7_891 VPWR VGND sg13g2_decap_8
XFILLER_38_784 VPWR VGND sg13g2_decap_8
XFILLER_10_1015 VPWR VGND sg13g2_decap_8
XFILLER_5_806 VPWR VGND sg13g2_decap_8
XFILLER_0_533 VPWR VGND sg13g2_decap_8
XFILLER_29_784 VPWR VGND sg13g2_decap_8
XFILLER_44_765 VPWR VGND sg13g2_decap_8
XFILLER_4_872 VPWR VGND sg13g2_decap_8
XFILLER_35_798 VPWR VGND sg13g2_decap_8
XFILLER_47_592 VPWR VGND sg13g2_decap_8
XFILLER_47_570 VPWR VGND sg13g2_decap_8
XFILLER_14_938 VPWR VGND sg13g2_decap_8
XFILLER_26_798 VPWR VGND sg13g2_decap_8
XFILLER_41_757 VPWR VGND sg13g2_decap_8
XFILLER_5_603 VPWR VGND sg13g2_decap_8
XFILLER_49_1022 VPWR VGND sg13g2_decap_8
XFILLER_1_864 VPWR VGND sg13g2_decap_8
XFILLER_49_857 VPWR VGND sg13g2_decap_8
XFILLER_17_798 VPWR VGND sg13g2_decap_8
X_587_ _587_/Q _628_/CLK _587_/D fanout65/X VPWR VGND sg13g2_dfrbpq_1
X_656_ _656_/Q _656_/CLK _656_/D fanout71/X VPWR VGND sg13g2_dfrbpq_1
XFILLER_48_367 VPWR VGND sg13g2_decap_8
XFILLER_13_993 VPWR VGND sg13g2_decap_8
XFILLER_9_942 VPWR VGND sg13g2_decap_8
XFILLER_23_779 VPWR VGND sg13g2_decap_4
Xfanout38 _278_/S _270_/S VPWR VGND sg13g2_buf_1
Xfanout49 _366_/S fanout61/X VPWR VGND sg13g2_buf_1
XFILLER_13_37 VPWR VGND sg13g2_fill_1
XFILLER_2_617 VPWR VGND sg13g2_decap_8
Xclkbuf_5_31__f_clk_regs _561_/CLK clkbuf_4_15_0_clk_regs/X VPWR VGND sg13g2_buf_16
XFILLER_38_56 VPWR VGND sg13g2_fill_1
X_510_ _510_/Q _541_/CLK _510_/D fanout85/X VPWR VGND sg13g2_dfrbpq_1
X_441_ _441_/Y _444_/A _444_/B VPWR VGND sg13g2_xnor2_1
XFILLER_46_838 VPWR VGND sg13g2_decap_8
XFILLER_10_952 VPWR VGND sg13g2_decap_8
XFILLER_41_576 VPWR VGND sg13g2_decap_8
XFILLER_41_587 VPWR VGND sg13g2_fill_1
X_372_ _537_/D _536_/Q _537_/Q _429_/S VPWR VGND sg13g2_mux2_1
XFILLER_6_912 VPWR VGND sg13g2_decap_8
Xclkload19 clkload19/Y _456_/A VPWR VGND sg13g2_inv_2
XFILLER_6_989 VPWR VGND sg13g2_decap_8
XFILLER_1_661 VPWR VGND sg13g2_decap_8
XFILLER_37_805 VPWR VGND sg13g2_decap_8
XFILLER_49_654 VPWR VGND sg13g2_decap_8
XFILLER_44_370 VPWR VGND sg13g2_decap_8
X_639_ _639_/Q _453_/Y _639_/D fanout75/X VPWR VGND sg13g2_dfrbpq_1
XFILLER_13_790 VPWR VGND sg13g2_decap_8
XFILLER_20_749 VPWR VGND sg13g2_decap_8
Xdelaybuf_24_clk delaybuf_25_clk/A clk VPWR VGND sg13g2_buf_16
XFILLER_28_805 VPWR VGND sg13g2_decap_8
XFILLER_43_819 VPWR VGND sg13g2_decap_8
XFILLER_11_749 VPWR VGND sg13g2_decap_8
XFILLER_7_709 VPWR VGND sg13g2_decap_8
XFILLER_3_948 VPWR VGND sg13g2_decap_8
Xdelaybuf_15_clk delaybuf_9_clk/A delaybuf_15_clk/A VPWR VGND sg13g2_buf_16
XFILLER_19_805 VPWR VGND sg13g2_decap_8
XFILLER_46_635 VPWR VGND sg13g2_decap_8
XFILLER_42_841 VPWR VGND sg13g2_decap_8
X_424_ _589_/D _588_/Q _616_/D _432_/S VPWR VGND sg13g2_mux2_1
XFILLER_41_362 VPWR VGND sg13g2_decap_8
X_355_ _520_/D _519_/Q _520_/Q _407_/S VPWR VGND sg13g2_mux2_1
X_286_ _286_/Y _286_/A1 _279_/Y _281_/Y _286_/B2 VPWR VGND sg13g2_a22oi_1
XFILLER_2_981 VPWR VGND sg13g2_decap_8
XFILLER_6_786 VPWR VGND sg13g2_decap_8
XFILLER_25_819 VPWR VGND sg13g2_decap_8
Xinput6 _603_/D ui_in[4] VPWR VGND sg13g2_buf_1
XFILLER_49_440 VPWR VGND sg13g2_decap_8
XFILLER_33_830 VPWR VGND sg13g2_decap_8
XFILLER_0_918 VPWR VGND sg13g2_decap_8
XFILLER_16_819 VPWR VGND sg13g2_decap_8
XFILLER_7_506 VPWR VGND sg13g2_decap_8
XFILLER_2_233 VPWR VGND sg13g2_fill_2
XFILLER_2_288 VPWR VGND sg13g2_decap_8
XFILLER_3_745 VPWR VGND sg13g2_decap_8
Xclkbuf_2_2__f_clk_delayed _456_/A clkbuf_0_clk_delayed/X VPWR VGND sg13g2_buf_16
XFILLER_46_476 VPWR VGND sg13g2_decap_8
X_407_ _572_/D _571_/Q _572_/Q _407_/S VPWR VGND sg13g2_mux2_1
X_338_ _503_/D _502_/Q _503_/Q _415_/S VPWR VGND sg13g2_mux2_1
X_269_ _641_/D _607_/Q _621_/Q _270_/S VPWR VGND sg13g2_mux2_1
XFILLER_6_572 VPWR VGND sg13g2_decap_8
XFILLER_0_715 VPWR VGND sg13g2_decap_8
X_257__99 _648_/CLK _257__99/A VPWR VGND sg13g2_inv_1
XFILLER_12_811 VPWR VGND sg13g2_decap_8
XFILLER_43_413 VPWR VGND sg13g2_decap_8
XFILLER_8_804 VPWR VGND sg13g2_decap_8
XFILLER_12_888 VPWR VGND sg13g2_decap_8
XFILLER_7_303 VPWR VGND sg13g2_decap_8
XFILLER_3_542 VPWR VGND sg13g2_decap_8
XFILLER_46_240 VPWR VGND sg13g2_fill_1
XFILLER_46_273 VPWR VGND sg13g2_decap_8
XFILLER_47_774 VPWR VGND sg13g2_decap_8
XFILLER_7_870 VPWR VGND sg13g2_decap_8
XFILLER_38_763 VPWR VGND sg13g2_decap_8
XFILLER_0_512 VPWR VGND sg13g2_decap_8
XFILLER_0_589 VPWR VGND sg13g2_decap_8
XFILLER_17_936 VPWR VGND sg13g2_decap_8
XFILLER_29_763 VPWR VGND sg13g2_decap_8
XFILLER_44_744 VPWR VGND sg13g2_decap_8
XFILLER_48_549 VPWR VGND sg13g2_decap_8
XFILLER_4_851 VPWR VGND sg13g2_decap_8
XFILLER_35_777 VPWR VGND sg13g2_decap_8
Xclkbuf_5_30__f_clk_regs _562_/CLK clkbuf_4_15_0_clk_regs/X VPWR VGND sg13g2_buf_16
XFILLER_14_917 VPWR VGND sg13g2_decap_8
XFILLER_26_777 VPWR VGND sg13g2_decap_8
XFILLER_41_736 VPWR VGND sg13g2_decap_8
XFILLER_5_659 VPWR VGND sg13g2_decap_8
XFILLER_1_843 VPWR VGND sg13g2_decap_8
XFILLER_49_836 VPWR VGND sg13g2_decap_8
XFILLER_48_346 VPWR VGND sg13g2_decap_8
XFILLER_17_777 VPWR VGND sg13g2_decap_8
XFILLER_1_1025 VPWR VGND sg13g2_decap_4
X_586_ _586_/Q _625_/CLK _586_/D fanout65/X VPWR VGND sg13g2_dfrbpq_1
X_655_ _655_/Q _656_/CLK _655_/D fanout76/X VPWR VGND sg13g2_dfrbpq_1
XFILLER_13_972 VPWR VGND sg13g2_decap_8
XFILLER_40_791 VPWR VGND sg13g2_decap_8
XFILLER_9_998 VPWR VGND sg13g2_decap_8
XFILLER_9_921 VPWR VGND sg13g2_decap_8
Xclkbuf_leaf_3_clk _440_/B delaybuf_9_clk/A VPWR VGND sg13g2_buf_8
XFILLER_48_891 VPWR VGND sg13g2_decap_8
Xfanout39 _270_/S hold104/X VPWR VGND sg13g2_buf_1
XFILLER_31_791 VPWR VGND sg13g2_decap_8
XFILLER_46_817 VPWR VGND sg13g2_decap_8
X_440_ _440_/Y _444_/A _440_/B VPWR VGND sg13g2_xnor2_1
X_371_ _536_/D _535_/Q _536_/Q _429_/S VPWR VGND sg13g2_mux2_1
XFILLER_10_931 VPWR VGND sg13g2_decap_8
XFILLER_5_401 VPWR VGND sg13g2_decap_8
XFILLER_1_640 VPWR VGND sg13g2_decap_8
XFILLER_6_968 VPWR VGND sg13g2_decap_8
XFILLER_5_445 VPWR VGND sg13g2_fill_1
XFILLER_49_633 VPWR VGND sg13g2_decap_8
X_569_ _569_/Q _569_/CLK _569_/D fanout96/X VPWR VGND sg13g2_dfrbpq_1
X_638_ _638_/Q _452_/Y _638_/D fanout69/X VPWR VGND sg13g2_dfrbpq_1
XFILLER_9_795 VPWR VGND sg13g2_decap_8
XFILLER_36_850 VPWR VGND sg13g2_fill_2
XFILLER_3_927 VPWR VGND sg13g2_decap_8
XFILLER_46_614 VPWR VGND sg13g2_decap_8
XFILLER_42_820 VPWR VGND sg13g2_decap_8
X_423_ _588_/D _587_/Q _588_/Q _432_/S VPWR VGND sg13g2_mux2_1
X_354_ _519_/D _518_/Q _519_/Q _412_/S VPWR VGND sg13g2_mux2_1
XFILLER_14_70 VPWR VGND sg13g2_fill_2
Xdelaybuf_8_clk _460_/B delaybuf_8_clk/A VPWR VGND sg13g2_buf_16
X_285_ _285_/Y _224_/Y _258_/A _284_/Y VPWR VGND sg13g2_o21ai_1
XFILLER_6_765 VPWR VGND sg13g2_decap_8
XFILLER_2_960 VPWR VGND sg13g2_decap_8
XFILLER_45_680 VPWR VGND sg13g2_decap_8
Xinput7 _604_/D ui_in[5] VPWR VGND sg13g2_buf_1
XFILLER_49_496 VPWR VGND sg13g2_decap_8
XFILLER_13_1014 VPWR VGND sg13g2_decap_8
XFILLER_2_267 VPWR VGND sg13g2_fill_2
XFILLER_3_724 VPWR VGND sg13g2_decap_8
XFILLER_46_455 VPWR VGND sg13g2_decap_8
XFILLER_15_875 VPWR VGND sg13g2_decap_8
XFILLER_30_812 VPWR VGND sg13g2_decap_8
Xclkbuf_4_4_0_clk_regs clkbuf_4_4_0_clk_regs/X clkbuf_0_clk_regs/X VPWR VGND sg13g2_buf_8
X_406_ _571_/D _570_/Q _571_/Q _407_/S VPWR VGND sg13g2_mux2_1
X_337_ _502_/D _501_/Q _502_/Q _415_/S VPWR VGND sg13g2_mux2_1
X_268_ _640_/D _606_/Q _620_/Q _270_/S VPWR VGND sg13g2_mux2_1
XFILLER_6_551 VPWR VGND sg13g2_decap_8
XFILLER_2_73 VPWR VGND sg13g2_fill_1
XFILLER_21_812 VPWR VGND sg13g2_decap_8
XFILLER_21_823 VPWR VGND sg13g2_fill_2
XFILLER_48_709 VPWR VGND sg13g2_decap_8
XFILLER_12_867 VPWR VGND sg13g2_decap_8
XFILLER_3_521 VPWR VGND sg13g2_decap_8
XFILLER_3_598 VPWR VGND sg13g2_decap_8
XFILLER_4_1012 VPWR VGND sg13g2_decap_8
XFILLER_47_753 VPWR VGND sg13g2_decap_8
Xinput10 _236_/A0 uio_in[0] VPWR VGND sg13g2_buf_1
XFILLER_0_568 VPWR VGND sg13g2_decap_8
XFILLER_48_528 VPWR VGND sg13g2_decap_8
XFILLER_44_723 VPWR VGND sg13g2_decap_8
XFILLER_4_830 VPWR VGND sg13g2_decap_8
XFILLER_16_981 VPWR VGND sg13g2_decap_4
XFILLER_35_756 VPWR VGND sg13g2_decap_8
XFILLER_26_756 VPWR VGND sg13g2_decap_8
XFILLER_41_715 VPWR VGND sg13g2_decap_8
XFILLER_1_822 VPWR VGND sg13g2_decap_8
XFILLER_5_638 VPWR VGND sg13g2_decap_8
XFILLER_4_159 VPWR VGND sg13g2_fill_1
XFILLER_0_354 VPWR VGND sg13g2_decap_8
XFILLER_0_387 VPWR VGND sg13g2_decap_8
XFILLER_1_1004 VPWR VGND sg13g2_decap_8
XFILLER_1_899 VPWR VGND sg13g2_decap_8
X_654_ _654_/Q _656_/CLK _654_/D fanout76/X VPWR VGND sg13g2_dfrbpq_1
XFILLER_49_815 VPWR VGND sg13g2_decap_8
XFILLER_48_325 VPWR VGND sg13g2_decap_8
XFILLER_13_951 VPWR VGND sg13g2_decap_8
XFILLER_17_756 VPWR VGND sg13g2_decap_8
XFILLER_44_597 VPWR VGND sg13g2_decap_8
X_585_ _585_/Q _612_/CLK _585_/D fanout66/X VPWR VGND sg13g2_dfrbpq_1
XFILLER_9_900 VPWR VGND sg13g2_decap_8
XFILLER_40_770 VPWR VGND sg13g2_decap_8
XFILLER_9_977 VPWR VGND sg13g2_decap_8
XFILLER_48_870 VPWR VGND sg13g2_decap_8
XFILLER_31_770 VPWR VGND sg13g2_decap_8
XFILLER_45_306 VPWR VGND sg13g2_decap_8
X_370_ _535_/D _534_/Q _535_/Q _412_/S VPWR VGND sg13g2_mux2_1
XFILLER_10_910 VPWR VGND sg13g2_decap_8
XFILLER_10_987 VPWR VGND sg13g2_decap_8
XFILLER_22_770 VPWR VGND sg13g2_fill_2
XFILLER_22_792 VPWR VGND sg13g2_decap_8
XFILLER_6_947 VPWR VGND sg13g2_decap_8
XFILLER_1_696 VPWR VGND sg13g2_decap_8
XFILLER_49_612 VPWR VGND sg13g2_decap_8
X_637_ _637_/Q _451_/Y _637_/D fanout68/X VPWR VGND sg13g2_dfrbpq_1
XFILLER_49_689 VPWR VGND sg13g2_decap_8
X_568_ _568_/Q _569_/CLK _568_/D fanout96/X VPWR VGND sg13g2_dfrbpq_1
X_499_ _499_/Q _513_/CLK _499_/D fanout88/X VPWR VGND sg13g2_dfrbpq_1
XFILLER_9_774 VPWR VGND sg13g2_decap_8
XFILLER_2_449 VPWR VGND sg13g2_decap_8
XFILLER_3_906 VPWR VGND sg13g2_decap_8
XFILLER_27_851 VPWR VGND sg13g2_fill_1
X_422_ _587_/D _586_/Q _587_/Q _436_/S VPWR VGND sg13g2_mux2_1
X_353_ _518_/D _517_/Q _518_/Q _366_/S VPWR VGND sg13g2_mux2_1
X_284_ _284_/Y _284_/A1 _279_/Y _281_/Y _284_/B2 VPWR VGND sg13g2_a22oi_1
XFILLER_10_784 VPWR VGND sg13g2_decap_8
XFILLER_6_744 VPWR VGND sg13g2_decap_8
XFILLER_5_276 VPWR VGND sg13g2_decap_8
XFILLER_1_493 VPWR VGND sg13g2_decap_8
Xinput8 _617_/D ui_in[6] VPWR VGND sg13g2_buf_1
XFILLER_7_1010 VPWR VGND sg13g2_decap_8
XFILLER_49_475 VPWR VGND sg13g2_decap_8
XFILLER_3_703 VPWR VGND sg13g2_decap_8
XFILLER_2_235 VPWR VGND sg13g2_fill_1
XFILLER_15_854 VPWR VGND sg13g2_decap_8
XFILLER_46_434 VPWR VGND sg13g2_decap_8
XFILLER_30_846 VPWR VGND sg13g2_decap_4
X_405_ _570_/D _569_/Q _570_/Q _405_/S VPWR VGND sg13g2_mux2_1
X_336_ _501_/D _500_/Q _501_/Q _415_/S VPWR VGND sg13g2_mux2_1
X_267_ _639_/D _605_/Q _619_/Q _270_/S VPWR VGND sg13g2_mux2_1
XFILLER_6_530 VPWR VGND sg13g2_decap_8
XFILLER_12_846 VPWR VGND sg13g2_decap_8
XFILLER_8_839 VPWR VGND sg13g2_decap_8
XFILLER_7_338 VPWR VGND sg13g2_decap_8
XFILLER_3_500 VPWR VGND sg13g2_decap_8
XFILLER_3_577 VPWR VGND sg13g2_decap_8
XFILLER_47_732 VPWR VGND sg13g2_decap_8
Xinput11 _235_/A0 uio_in[1] VPWR VGND sg13g2_buf_1
X_319_ _484_/D _483_/Q _484_/Q _392_/S VPWR VGND sg13g2_mux2_1
Xclkbuf_1_0__f_clk delaybuf_16_clk/A delaybuf_23_clk/X VPWR VGND sg13g2_buf_16
XFILLER_38_798 VPWR VGND sg13g2_decap_8
XFILLER_0_547 VPWR VGND sg13g2_decap_8
XFILLER_48_507 VPWR VGND sg13g2_decap_8
XFILLER_29_798 VPWR VGND sg13g2_decap_8
XFILLER_44_702 VPWR VGND sg13g2_decap_8
XFILLER_44_779 VPWR VGND sg13g2_decap_8
XFILLER_3_374 VPWR VGND sg13g2_fill_1
XFILLER_4_886 VPWR VGND sg13g2_decap_8
XFILLER_16_960 VPWR VGND sg13g2_decap_8
XFILLER_5_617 VPWR VGND sg13g2_decap_8
XFILLER_1_801 VPWR VGND sg13g2_decap_8
XFILLER_1_878 VPWR VGND sg13g2_decap_8
X_653_ _653_/Q _658_/CLK _653_/D fanout78/X VPWR VGND sg13g2_dfrbpq_1
XFILLER_48_304 VPWR VGND sg13g2_decap_8
XFILLER_13_930 VPWR VGND sg13g2_decap_8
XFILLER_32_749 VPWR VGND sg13g2_decap_8
XFILLER_44_576 VPWR VGND sg13g2_decap_8
X_584_ _584_/Q _612_/CLK _584_/D fanout66/X VPWR VGND sg13g2_dfrbpq_1
XFILLER_9_956 VPWR VGND sg13g2_decap_8
XFILLER_4_683 VPWR VGND sg13g2_decap_8
XFILLER_23_749 VPWR VGND sg13g2_decap_8
XFILLER_47_381 VPWR VGND sg13g2_decap_8
Xdelaybuf_27_clk delaybuf_28_clk/A delaybuf_27_clk/A VPWR VGND sg13g2_buf_16
XFILLER_14_749 VPWR VGND sg13g2_decap_8
XFILLER_16_1002 VPWR VGND sg13g2_fill_2
XFILLER_10_966 VPWR VGND sg13g2_decap_8
Xdelaybuf_18_clk delaybuf_19_clk/A delaybuf_18_clk/A VPWR VGND sg13g2_buf_16
XFILLER_6_926 VPWR VGND sg13g2_decap_8
XFILLER_1_675 VPWR VGND sg13g2_decap_8
XFILLER_37_819 VPWR VGND sg13g2_decap_4
XFILLER_44_384 VPWR VGND sg13g2_decap_8
XFILLER_45_841 VPWR VGND sg13g2_decap_8
X_567_ _567_/Q _567_/CLK _567_/D fanout96/X VPWR VGND sg13g2_dfrbpq_1
X_636_ _636_/Q _450_/Y _636_/D fanout68/X VPWR VGND sg13g2_dfrbpq_1
XFILLER_49_668 VPWR VGND sg13g2_decap_8
X_498_ _498_/Q _513_/CLK _498_/D fanout88/X VPWR VGND sg13g2_dfrbpq_1
XFILLER_5_981 VPWR VGND sg13g2_decap_8
XFILLER_28_819 VPWR VGND sg13g2_decap_4
XFILLER_36_830 VPWR VGND sg13g2_fill_2
XFILLER_2_406 VPWR VGND sg13g2_decap_4
XFILLER_19_819 VPWR VGND sg13g2_decap_4
X_421_ _586_/D _585_/Q _586_/Q _436_/S VPWR VGND sg13g2_mux2_1
XFILLER_46_649 VPWR VGND sg13g2_decap_8
XFILLER_10_763 VPWR VGND sg13g2_decap_8
XFILLER_14_72 VPWR VGND sg13g2_fill_1
X_352_ _517_/D _516_/Q _517_/Q _366_/S VPWR VGND sg13g2_mux2_1
X_283_ _283_/Y _223_/Y _258_/A _282_/Y VPWR VGND sg13g2_o21ai_1
XFILLER_18_830 VPWR VGND sg13g2_fill_1
XFILLER_1_472 VPWR VGND sg13g2_decap_8
XFILLER_2_995 VPWR VGND sg13g2_decap_8
Xinput9 _618_/D ui_in[7] VPWR VGND sg13g2_buf_1
XFILLER_49_454 VPWR VGND sg13g2_decap_8
XFILLER_18_841 VPWR VGND sg13g2_decap_8
XFILLER_33_844 VPWR VGND sg13g2_decap_8
X_619_ _619_/Q _623_/CLK _619_/D fanout74/X VPWR VGND sg13g2_dfrbpq_1
XFILLER_24_833 VPWR VGND sg13g2_decap_8
XFILLER_3_759 VPWR VGND sg13g2_decap_8
XFILLER_47_925 VPWR VGND sg13g2_fill_1
XFILLER_47_903 VPWR VGND sg13g2_fill_2
XFILLER_46_413 VPWR VGND sg13g2_decap_8
XFILLER_15_833 VPWR VGND sg13g2_decap_8
XFILLER_25_71 VPWR VGND sg13g2_fill_2
XFILLER_42_663 VPWR VGND sg13g2_decap_8
X_404_ _569_/D _568_/Q _569_/Q _404_/S VPWR VGND sg13g2_mux2_1
X_335_ _500_/D _499_/Q _500_/Q _350_/S VPWR VGND sg13g2_mux2_1
X_266_ _643_/D _266_/A _266_/B VPWR VGND sg13g2_nand2_1
XFILLER_2_792 VPWR VGND sg13g2_decap_8
XFILLER_6_586 VPWR VGND sg13g2_decap_8
XFILLER_0_729 VPWR VGND sg13g2_decap_8
XFILLER_43_427 VPWR VGND sg13g2_decap_4
XFILLER_12_825 VPWR VGND sg13g2_decap_8
XFILLER_8_818 VPWR VGND sg13g2_decap_8
XFILLER_7_317 VPWR VGND sg13g2_decap_8
XFILLER_3_556 VPWR VGND sg13g2_decap_8
XFILLER_47_788 VPWR VGND sg13g2_decap_8
XFILLER_47_711 VPWR VGND sg13g2_decap_8
XFILLER_46_287 VPWR VGND sg13g2_decap_8
Xinput12 _234_/A0 uio_in[2] VPWR VGND sg13g2_buf_1
X_318_ _483_/D _482_/Q _483_/Q _392_/S VPWR VGND sg13g2_mux2_1
X_249_ _249_/X _642_/Q _252_/B VPWR VGND sg13g2_and2_1
XFILLER_7_884 VPWR VGND sg13g2_decap_8
XFILLER_6_361 VPWR VGND sg13g2_decap_8
XFILLER_38_777 VPWR VGND sg13g2_decap_8
XFILLER_0_526 VPWR VGND sg13g2_decap_8
XFILLER_10_1008 VPWR VGND sg13g2_decap_8
XFILLER_29_777 VPWR VGND sg13g2_decap_8
XFILLER_44_758 VPWR VGND sg13g2_decap_8
XFILLER_4_865 VPWR VGND sg13g2_decap_8
XFILLER_47_563 VPWR VGND sg13g2_decap_8
Xclkbuf_leaf_6_clk _449_/B delaybuf_16_clk/X VPWR VGND sg13g2_buf_8
XFILLER_7_681 VPWR VGND sg13g2_decap_8
XFILLER_34_791 VPWR VGND sg13g2_decap_4
XFILLER_49_1015 VPWR VGND sg13g2_decap_8
XFILLER_1_857 VPWR VGND sg13g2_decap_8
X_583_ _583_/Q _613_/CLK _583_/D fanout68/X VPWR VGND sg13g2_dfrbpq_1
X_652_ _652_/Q _660_/CLK _652_/D fanout79/X VPWR VGND sg13g2_dfrbpq_1
XFILLER_13_986 VPWR VGND sg13g2_decap_8
XFILLER_25_791 VPWR VGND sg13g2_decap_8
XFILLER_9_935 VPWR VGND sg13g2_decap_8
XFILLER_4_662 VPWR VGND sg13g2_decap_8
XFILLER_0_890 VPWR VGND sg13g2_decap_8
XFILLER_16_791 VPWR VGND sg13g2_decap_8
XFILLER_47_360 VPWR VGND sg13g2_decap_8
XFILLER_10_945 VPWR VGND sg13g2_decap_8
XFILLER_22_772 VPWR VGND sg13g2_fill_1
XFILLER_22_783 VPWR VGND sg13g2_decap_4
XFILLER_41_569 VPWR VGND sg13g2_decap_8
Xclkbuf_0__017_ clkbuf_0__017_/X _256_/Y VPWR VGND sg13g2_buf_16
XFILLER_6_905 VPWR VGND sg13g2_decap_8
XFILLER_1_654 VPWR VGND sg13g2_decap_8
XFILLER_49_647 VPWR VGND sg13g2_decap_8
XFILLER_44_363 VPWR VGND sg13g2_decap_8
XFILLER_45_820 VPWR VGND sg13g2_decap_8
X_566_ _566_/Q _567_/CLK _566_/D fanout96/X VPWR VGND sg13g2_dfrbpq_1
X_635_ _635_/Q _449_/Y _635_/D fanout65/X VPWR VGND sg13g2_dfrbpq_1
X_497_ _497_/Q _513_/CLK _497_/D fanout88/X VPWR VGND sg13g2_dfrbpq_1
XFILLER_5_960 VPWR VGND sg13g2_decap_8
XFILLER_5_86 VPWR VGND sg13g2_fill_2
XFILLER_42_834 VPWR VGND sg13g2_decap_8
X_420_ _585_/D _584_/Q _585_/Q _436_/S VPWR VGND sg13g2_mux2_1
X_351_ _516_/D _515_/Q _516_/Q _366_/S VPWR VGND sg13g2_mux2_1
XFILLER_46_628 VPWR VGND sg13g2_decap_8
X_282_ _282_/Y _282_/A1 _279_/Y _281_/Y _282_/B2 VPWR VGND sg13g2_a22oi_1
XFILLER_1_451 VPWR VGND sg13g2_decap_8
XFILLER_2_974 VPWR VGND sg13g2_decap_8
XFILLER_6_779 VPWR VGND sg13g2_decap_8
XFILLER_5_234 VPWR VGND sg13g2_fill_2
XFILLER_49_433 VPWR VGND sg13g2_decap_8
XFILLER_45_694 VPWR VGND sg13g2_decap_8
X_618_ _618_/Q _618_/CLK _618_/D fanout77/X VPWR VGND sg13g2_dfrbpq_1
X_549_ _549_/Q _562_/CLK _549_/D fanout94/X VPWR VGND sg13g2_dfrbpq_1
XFILLER_24_812 VPWR VGND sg13g2_decap_8
XFILLER_13_1028 VPWR VGND sg13g2_fill_1
XFILLER_3_738 VPWR VGND sg13g2_decap_8
XFILLER_15_812 VPWR VGND sg13g2_decap_8
XFILLER_15_889 VPWR VGND sg13g2_decap_4
XFILLER_30_826 VPWR VGND sg13g2_fill_2
XFILLER_42_642 VPWR VGND sg13g2_decap_8
X_403_ _568_/D _567_/Q _568_/Q _404_/S VPWR VGND sg13g2_mux2_1
X_334_ _499_/D _498_/Q _499_/Q _350_/S VPWR VGND sg13g2_mux2_1
XFILLER_46_469 VPWR VGND sg13g2_decap_8
X_265_ _644_/D _604_/Q _266_/A _264_/X VPWR VGND sg13g2_o21ai_1
XFILLER_6_565 VPWR VGND sg13g2_decap_8
XFILLER_2_771 VPWR VGND sg13g2_decap_8
XFILLER_49_274 VPWR VGND sg13g2_fill_1
XFILLER_0_708 VPWR VGND sg13g2_decap_8
XFILLER_12_804 VPWR VGND sg13g2_decap_8
XFILLER_43_406 VPWR VGND sg13g2_decap_8
XFILLER_3_535 VPWR VGND sg13g2_decap_8
XFILLER_4_1026 VPWR VGND sg13g2_fill_2
XFILLER_47_767 VPWR VGND sg13g2_decap_8
Xinput13 _233_/A0 uio_in[3] VPWR VGND sg13g2_buf_1
X_317_ _482_/D _481_/Q _482_/Q _392_/S VPWR VGND sg13g2_mux2_1
X_248_ _248_/X _641_/Q _248_/B VPWR VGND sg13g2_and2_1
XFILLER_7_863 VPWR VGND sg13g2_decap_8
XFILLER_38_756 VPWR VGND sg13g2_decap_8
XFILLER_0_505 VPWR VGND sg13g2_decap_8
XFILLER_17_929 VPWR VGND sg13g2_decap_8
XFILLER_29_756 VPWR VGND sg13g2_decap_8
XFILLER_44_737 VPWR VGND sg13g2_decap_8
Xclkbuf_4_3_0_clk_regs clkbuf_4_3_0_clk_regs/X clkbuf_0_clk_regs/X VPWR VGND sg13g2_buf_8
XFILLER_3_310 VPWR VGND sg13g2_fill_1
XFILLER_4_844 VPWR VGND sg13g2_decap_8
XFILLER_0_0 VPWR VGND sg13g2_fill_2
XFILLER_16_995 VPWR VGND sg13g2_decap_8
XFILLER_43_770 VPWR VGND sg13g2_decap_8
XFILLER_47_542 VPWR VGND sg13g2_decap_8
XFILLER_7_660 VPWR VGND sg13g2_decap_8
XFILLER_34_770 VPWR VGND sg13g2_decap_8
XFILLER_41_729 VPWR VGND sg13g2_decap_8
XFILLER_0_368 VPWR VGND sg13g2_fill_2
XFILLER_1_836 VPWR VGND sg13g2_decap_8
XFILLER_49_829 VPWR VGND sg13g2_decap_8
XFILLER_48_339 VPWR VGND sg13g2_decap_8
XFILLER_1_1018 VPWR VGND sg13g2_decap_8
XFILLER_25_770 VPWR VGND sg13g2_decap_8
X_582_ _609_/D _616_/CLK _582_/D fanout73/X VPWR VGND sg13g2_dfrbpq_1
X_651_ _651_/Q _658_/CLK _651_/D fanout79/X VPWR VGND sg13g2_dfrbpq_1
XFILLER_13_965 VPWR VGND sg13g2_decap_8
XFILLER_40_784 VPWR VGND sg13g2_decap_8
XFILLER_9_914 VPWR VGND sg13g2_decap_8
XFILLER_4_641 VPWR VGND sg13g2_decap_8
XFILLER_48_884 VPWR VGND sg13g2_decap_8
XFILLER_16_770 VPWR VGND sg13g2_decap_8
XFILLER_31_784 VPWR VGND sg13g2_decap_8
XFILLER_39_840 VPWR VGND sg13g2_decap_8
XFILLER_39_851 VPWR VGND sg13g2_fill_1
XFILLER_10_924 VPWR VGND sg13g2_decap_8
XFILLER_1_633 VPWR VGND sg13g2_decap_8
XFILLER_5_438 VPWR VGND sg13g2_decap_8
XFILLER_0_143 VPWR VGND sg13g2_fill_2
XFILLER_0_176 VPWR VGND sg13g2_fill_2
X_634_ _634_/Q _448_/Y _634_/D fanout71/X VPWR VGND sg13g2_dfrbpq_1
XFILLER_49_626 VPWR VGND sg13g2_decap_8
XFILLER_13_762 VPWR VGND sg13g2_fill_2
XFILLER_44_342 VPWR VGND sg13g2_decap_8
X_565_ _565_/Q _567_/CLK _565_/D fanout96/X VPWR VGND sg13g2_dfrbpq_1
X_496_ _496_/Q _515_/CLK _496_/D fanout89/X VPWR VGND sg13g2_dfrbpq_1
XFILLER_9_788 VPWR VGND sg13g2_decap_8
XFILLER_36_832 VPWR VGND sg13g2_fill_1
XFILLER_36_843 VPWR VGND sg13g2_decap_8
XFILLER_48_681 VPWR VGND sg13g2_decap_8
XFILLER_46_607 VPWR VGND sg13g2_decap_8
XFILLER_42_813 VPWR VGND sg13g2_decap_8
X_350_ _515_/D _514_/Q _515_/Q _350_/S VPWR VGND sg13g2_mux2_1
XFILLER_10_798 VPWR VGND sg13g2_decap_8
X_281_ _281_/Y _281_/A _279_/B VPWR VGND sg13g2_nor2b_1
XFILLER_6_758 VPWR VGND sg13g2_decap_8
XFILLER_5_202 VPWR VGND sg13g2_fill_1
XFILLER_1_430 VPWR VGND sg13g2_decap_8
XFILLER_2_953 VPWR VGND sg13g2_decap_8
XFILLER_7_1024 VPWR VGND sg13g2_decap_4
XFILLER_49_412 VPWR VGND sg13g2_decap_8
XFILLER_33_802 VPWR VGND sg13g2_fill_1
XFILLER_45_673 VPWR VGND sg13g2_decap_8
X_617_ _617_/Q _618_/CLK _617_/D fanout77/X VPWR VGND sg13g2_dfrbpq_1
XFILLER_49_489 VPWR VGND sg13g2_decap_8
X_548_ _548_/Q _562_/CLK _548_/D fanout94/X VPWR VGND sg13g2_dfrbpq_1
X_479_ _479_/Q _505_/CLK _479_/D fanout91/X VPWR VGND sg13g2_dfrbpq_1
XFILLER_13_1007 VPWR VGND sg13g2_decap_8
XFILLER_3_717 VPWR VGND sg13g2_decap_8
XFILLER_46_448 VPWR VGND sg13g2_decap_8
XFILLER_15_868 VPWR VGND sg13g2_decap_8
XFILLER_30_805 VPWR VGND sg13g2_decap_8
XFILLER_42_621 VPWR VGND sg13g2_decap_8
XFILLER_42_698 VPWR VGND sg13g2_decap_8
X_402_ _567_/D _566_/Q _567_/Q _404_/S VPWR VGND sg13g2_mux2_1
X_333_ _498_/D _497_/Q _498_/Q _350_/S VPWR VGND sg13g2_mux2_1
X_264_ _264_/X _618_/Q _266_/B VPWR VGND sg13g2_or2_1
XFILLER_6_544 VPWR VGND sg13g2_decap_8
XFILLER_2_750 VPWR VGND sg13g2_decap_8
XFILLER_21_805 VPWR VGND sg13g2_decap_8
XFILLER_3_514 VPWR VGND sg13g2_decap_8
XFILLER_4_1005 VPWR VGND sg13g2_decap_8
XFILLER_36_72 VPWR VGND sg13g2_fill_1
XFILLER_47_746 VPWR VGND sg13g2_decap_8
XFILLER_11_882 VPWR VGND sg13g2_decap_8
X_316_ _481_/D _480_/Q _481_/Q _323_/S VPWR VGND sg13g2_mux2_1
X_247_ _247_/X _640_/Q _248_/B VPWR VGND sg13g2_and2_1
XFILLER_7_842 VPWR VGND sg13g2_decap_8
XFILLER_44_716 VPWR VGND sg13g2_decap_8
XFILLER_4_823 VPWR VGND sg13g2_decap_8
XFILLER_16_974 VPWR VGND sg13g2_decap_8
XFILLER_35_749 VPWR VGND sg13g2_decap_8
XFILLER_26_749 VPWR VGND sg13g2_decap_8
XFILLER_41_708 VPWR VGND sg13g2_decap_8
XFILLER_0_303 VPWR VGND sg13g2_decap_8
XFILLER_1_815 VPWR VGND sg13g2_decap_8
XFILLER_0_347 VPWR VGND sg13g2_decap_8
X_650_ _650_/Q _658_/CLK _650_/D fanout78/X VPWR VGND sg13g2_dfrbpq_1
XFILLER_49_808 VPWR VGND sg13g2_decap_8
XFILLER_48_318 VPWR VGND sg13g2_decap_8
XFILLER_13_944 VPWR VGND sg13g2_decap_8
XFILLER_17_749 VPWR VGND sg13g2_decap_8
X_581_ _581_/Q _621_/CLK _581_/D fanout90/X VPWR VGND sg13g2_dfrbpq_1
XFILLER_40_763 VPWR VGND sg13g2_decap_8
XFILLER_4_697 VPWR VGND sg13g2_decap_8
XFILLER_4_620 VPWR VGND sg13g2_decap_8
XFILLER_48_863 VPWR VGND sg13g2_decap_8
XFILLER_47_395 VPWR VGND sg13g2_decap_8
XFILLER_31_763 VPWR VGND sg13g2_decap_8
XFILLER_10_903 VPWR VGND sg13g2_decap_8
XFILLER_22_763 VPWR VGND sg13g2_decap_8
XFILLER_0_111 VPWR VGND sg13g2_fill_1
XFILLER_1_612 VPWR VGND sg13g2_decap_8
XFILLER_1_689 VPWR VGND sg13g2_decap_8
X_633_ _633_/Q _447_/Y _633_/D fanout71/X VPWR VGND sg13g2_dfrbpq_1
XFILLER_44_398 VPWR VGND sg13g2_decap_8
X_564_ _564_/Q _567_/CLK _564_/D fanout96/X VPWR VGND sg13g2_dfrbpq_1
X_495_ _495_/Q _515_/CLK _495_/D fanout89/X VPWR VGND sg13g2_dfrbpq_1
XFILLER_5_55 VPWR VGND sg13g2_fill_2
XFILLER_5_995 VPWR VGND sg13g2_decap_8
XFILLER_5_88 VPWR VGND sg13g2_fill_1
XFILLER_4_494 VPWR VGND sg13g2_decap_8
XFILLER_27_844 VPWR VGND sg13g2_decap_8
XFILLER_41_324 VPWR VGND sg13g2_fill_1
X_280_ _280_/X _280_/A0 _280_/A1 _460_/A _649_/Q _279_/B _281_/A VPWR VGND sg13g2_mux4_1
XFILLER_10_777 VPWR VGND sg13g2_decap_8
XFILLER_6_737 VPWR VGND sg13g2_decap_8
XFILLER_1_486 VPWR VGND sg13g2_decap_8
XFILLER_2_932 VPWR VGND sg13g2_decap_8
XFILLER_7_1003 VPWR VGND sg13g2_decap_8
XFILLER_44_162 VPWR VGND sg13g2_fill_2
XFILLER_45_652 VPWR VGND sg13g2_decap_8
X_616_ _616_/Q _616_/CLK _616_/D fanout69/X VPWR VGND sg13g2_dfrbpq_1
X_547_ _547_/Q _561_/CLK _547_/D fanout94/X VPWR VGND sg13g2_dfrbpq_1
XFILLER_49_468 VPWR VGND sg13g2_decap_8
X_478_ _478_/Q _505_/CLK _478_/D fanout91/X VPWR VGND sg13g2_dfrbpq_1
XFILLER_5_792 VPWR VGND sg13g2_decap_8
XFILLER_24_847 VPWR VGND sg13g2_decap_4
Xclkbuf_0_clk_regs clkbuf_0_clk_regs/X clkbuf_regs_0_clk/X VPWR VGND sg13g2_buf_16
X_401_ _566_/D _565_/Q _566_/Q _404_/S VPWR VGND sg13g2_mux2_1
XFILLER_46_427 VPWR VGND sg13g2_decap_8
XFILLER_15_847 VPWR VGND sg13g2_decap_8
XFILLER_30_828 VPWR VGND sg13g2_fill_1
XFILLER_30_839 VPWR VGND sg13g2_decap_8
X_332_ _497_/D _496_/Q _497_/Q _350_/S VPWR VGND sg13g2_mux2_1
X_263_ _645_/D _222_/Y _266_/A _262_/Y VPWR VGND sg13g2_o21ai_1
XFILLER_45_493 VPWR VGND sg13g2_fill_2
XFILLER_12_839 VPWR VGND sg13g2_decap_8
Xdelaybuf_1_clk u_delay_line/clk _440_/B VPWR VGND sg13g2_buf_16
XFILLER_4_1028 VPWR VGND sg13g2_fill_1
XFILLER_47_725 VPWR VGND sg13g2_decap_8
XFILLER_42_463 VPWR VGND sg13g2_decap_4
XFILLER_11_861 VPWR VGND sg13g2_decap_8
X_315_ _480_/D _479_/Q _480_/Q _323_/S VPWR VGND sg13g2_mux2_1
X_246_ _246_/X _639_/Q _248_/B VPWR VGND sg13g2_and2_1
XFILLER_7_821 VPWR VGND sg13g2_decap_8
XFILLER_7_898 VPWR VGND sg13g2_decap_8
XFILLER_6_386 VPWR VGND sg13g2_decap_4
XFILLER_37_791 VPWR VGND sg13g2_decap_8
XFILLER_4_802 VPWR VGND sg13g2_decap_8
XFILLER_0_2 VPWR VGND sg13g2_fill_1
XFILLER_3_367 VPWR VGND sg13g2_decap_8
XFILLER_4_879 VPWR VGND sg13g2_decap_8
XFILLER_47_599 VPWR VGND sg13g2_decap_8
XFILLER_47_577 VPWR VGND sg13g2_fill_2
XFILLER_47_500 VPWR VGND sg13g2_decap_8
XFILLER_16_953 VPWR VGND sg13g2_decap_8
XFILLER_28_791 VPWR VGND sg13g2_decap_8
X_229_ _467_/D _234_/A0 _655_/D _231_/S VPWR VGND sg13g2_mux2_1
XFILLER_7_695 VPWR VGND sg13g2_decap_8
XFILLER_6_194 VPWR VGND sg13g2_fill_1
XFILLER_19_0 VPWR VGND sg13g2_fill_2
XFILLER_19_791 VPWR VGND sg13g2_decap_8
X_580_ _580_/Q _621_/CLK _580_/D fanout86/X VPWR VGND sg13g2_dfrbpq_1
XFILLER_13_923 VPWR VGND sg13g2_decap_8
XFILLER_44_569 VPWR VGND sg13g2_decap_8
XFILLER_9_949 VPWR VGND sg13g2_decap_8
XFILLER_4_676 VPWR VGND sg13g2_decap_8
XFILLER_48_842 VPWR VGND sg13g2_decap_8
XFILLER_47_374 VPWR VGND sg13g2_decap_8
XFILLER_8_993 VPWR VGND sg13g2_decap_8
XFILLER_10_959 VPWR VGND sg13g2_decap_8
XFILLER_6_919 VPWR VGND sg13g2_decap_8
XFILLER_0_178 VPWR VGND sg13g2_fill_1
XFILLER_1_668 VPWR VGND sg13g2_decap_8
XFILLER_48_116 VPWR VGND sg13g2_fill_2
XFILLER_44_300 VPWR VGND sg13g2_fill_2
XFILLER_45_834 VPWR VGND sg13g2_decap_8
X_563_ _563_/Q _563_/CLK _563_/D fanout95/X VPWR VGND sg13g2_dfrbpq_1
X_632_ _632_/Q _446_/Y _632_/D fanout70/X VPWR VGND sg13g2_dfrbpq_1
XFILLER_13_764 VPWR VGND sg13g2_fill_1
XFILLER_13_797 VPWR VGND sg13g2_decap_8
XFILLER_44_377 VPWR VGND sg13g2_decap_8
X_494_ _494_/Q _563_/CLK _494_/D fanout98/X VPWR VGND sg13g2_dfrbpq_1
XFILLER_5_974 VPWR VGND sg13g2_decap_8
XFILLER_36_823 VPWR VGND sg13g2_decap_8
XFILLER_8_790 VPWR VGND sg13g2_decap_8
XFILLER_27_812 VPWR VGND sg13g2_decap_8
XFILLER_41_369 VPWR VGND sg13g2_fill_1
XFILLER_42_848 VPWR VGND sg13g2_decap_4
XFILLER_10_756 VPWR VGND sg13g2_decap_8
XFILLER_2_911 VPWR VGND sg13g2_decap_8
XFILLER_18_812 VPWR VGND sg13g2_decap_8
XFILLER_1_465 VPWR VGND sg13g2_decap_8
XFILLER_2_988 VPWR VGND sg13g2_decap_8
XFILLER_49_447 VPWR VGND sg13g2_decap_8
XFILLER_33_837 VPWR VGND sg13g2_decap_8
XFILLER_45_631 VPWR VGND sg13g2_decap_8
X_615_ _615_/Q _628_/CLK _615_/D fanout68/X VPWR VGND sg13g2_dfrbpq_1
X_546_ _546_/Q _561_/CLK _546_/D fanout94/X VPWR VGND sg13g2_dfrbpq_1
Xu_multimode_dll VPWR VGND _514_/Q _280_/A0 _496_/Q _497_/Q _498_/Q _499_/Q _500_/Q
+ _282_/A1 _501_/Q _502_/Q _503_/Q _504_/Q _505_/Q _284_/A1 _506_/Q _507_/Q _508_/Q
+ _509_/Q _510_/Q _515_/Q _603_/D _516_/Q _526_/Q _527_/Q _528_/Q _529_/Q _530_/Q
+ _531_/Q _532_/Q _533_/Q _534_/Q _535_/Q _517_/Q _536_/Q _537_/Q _538_/Q _539_/Q
+ _540_/Q _541_/Q _518_/Q _519_/Q _520_/Q _521_/Q _522_/Q _523_/Q _524_/Q _525_/Q
+ _481_/Q _482_/Q _483_/Q _484_/Q _485_/Q _486_/Q _487_/Q _488_/Q _489_/Q _490_/Q
+ _491_/Q _492_/Q _493_/Q _494_/Q _495_/Q _476_/Q _477_/Q _478_/Q _479_/Q _480_/Q
+ _511_/Q _512_/Q _513_/Q delaybuf_0_clk/X _288_/A1 fanout89/X _286_/A1 multimode_dll
X_477_ _477_/Q _534_/CLK _477_/D fanout91/X VPWR VGND sg13g2_dfrbpq_1
XFILLER_5_771 VPWR VGND sg13g2_decap_8
XFILLER_49_970 VPWR VGND sg13g2_decap_8
XFILLER_24_826 VPWR VGND sg13g2_decap_8
XFILLER_46_406 VPWR VGND sg13g2_decap_8
XFILLER_15_826 VPWR VGND sg13g2_decap_8
XFILLER_42_656 VPWR VGND sg13g2_decap_8
X_400_ _565_/D _564_/Q _565_/Q _404_/S VPWR VGND sg13g2_mux2_1
X_331_ _496_/D _495_/Q _496_/Q _331_/S VPWR VGND sg13g2_mux2_1
X_262_ _262_/Y _270_/S _617_/Q _262_/C VPWR VGND sg13g2_nand3_1
XFILLER_6_502 VPWR VGND sg13g2_fill_1
XFILLER_2_785 VPWR VGND sg13g2_decap_8
XFILLER_6_579 VPWR VGND sg13g2_decap_8
XFILLER_45_472 VPWR VGND sg13g2_decap_8
X_529_ _529_/Q _541_/CLK _529_/D fanout71/X VPWR VGND sg13g2_dfrbpq_1
XFILLER_12_818 VPWR VGND sg13g2_decap_8
XFILLER_20_851 VPWR VGND sg13g2_fill_1
XFILLER_3_549 VPWR VGND sg13g2_decap_8
XFILLER_47_704 VPWR VGND sg13g2_decap_8
X_314_ _479_/D _478_/Q _479_/Q _323_/S VPWR VGND sg13g2_mux2_1
XFILLER_11_840 VPWR VGND sg13g2_decap_8
X_245_ _245_/X _638_/Q _248_/B VPWR VGND sg13g2_and2_1
XFILLER_7_877 VPWR VGND sg13g2_decap_8
XFILLER_7_800 VPWR VGND sg13g2_decap_8
XFILLER_6_354 VPWR VGND sg13g2_decap_8
XFILLER_2_582 VPWR VGND sg13g2_decap_8
XFILLER_6_398 VPWR VGND sg13g2_decap_4
XFILLER_0_519 VPWR VGND sg13g2_decap_8
XFILLER_37_770 VPWR VGND sg13g2_decap_8
XFILLER_4_858 VPWR VGND sg13g2_decap_8
XFILLER_28_770 VPWR VGND sg13g2_decap_8
XFILLER_47_556 VPWR VGND sg13g2_decap_8
X_228_ _468_/D _233_/A0 _656_/D _231_/S VPWR VGND sg13g2_mux2_1
XFILLER_7_674 VPWR VGND sg13g2_decap_8
XFILLER_19_770 VPWR VGND sg13g2_decap_8
XFILLER_34_784 VPWR VGND sg13g2_decap_8
XFILLER_34_795 VPWR VGND sg13g2_fill_1
XFILLER_13_902 VPWR VGND sg13g2_decap_8
XFILLER_13_979 VPWR VGND sg13g2_decap_8
XFILLER_25_784 VPWR VGND sg13g2_decap_8
XFILLER_9_928 VPWR VGND sg13g2_decap_8
XFILLER_40_798 VPWR VGND sg13g2_decap_8
XFILLER_4_655 VPWR VGND sg13g2_decap_8
XFILLER_0_883 VPWR VGND sg13g2_decap_8
XFILLER_48_821 VPWR VGND sg13g2_decap_8
XFILLER_16_784 VPWR VGND sg13g2_decap_8
XFILLER_48_898 VPWR VGND sg13g2_decap_8
XFILLER_47_353 VPWR VGND sg13g2_decap_8
XFILLER_31_798 VPWR VGND sg13g2_decap_8
XFILLER_43_581 VPWR VGND sg13g2_decap_8
Xclkbuf_4_2_0_clk_regs clkbuf_4_2_0_clk_regs/X clkbuf_0_clk_regs/X VPWR VGND sg13g2_buf_8
XFILLER_8_972 VPWR VGND sg13g2_decap_8
XFILLER_31_0 VPWR VGND sg13g2_fill_2
XFILLER_7_471 VPWR VGND sg13g2_decap_8
XFILLER_22_787 VPWR VGND sg13g2_fill_1
XFILLER_10_938 VPWR VGND sg13g2_decap_8
XFILLER_5_408 VPWR VGND sg13g2_fill_2
XFILLER_1_647 VPWR VGND sg13g2_decap_8
XFILLER_44_356 VPWR VGND sg13g2_decap_8
XFILLER_45_813 VPWR VGND sg13g2_decap_8
X_562_ _562_/Q _562_/CLK _562_/D fanout94/X VPWR VGND sg13g2_dfrbpq_1
X_631_ _631_/Q _445_/Y _631_/D fanout73/X VPWR VGND sg13g2_dfrbpq_1
X_493_ _493_/Q _563_/CLK _493_/D fanout89/X VPWR VGND sg13g2_dfrbpq_1
XFILLER_5_953 VPWR VGND sg13g2_decap_8
XFILLER_5_57 VPWR VGND sg13g2_fill_1
XFILLER_0_680 VPWR VGND sg13g2_decap_8
XFILLER_48_695 VPWR VGND sg13g2_decap_8
XFILLER_48_640 VPWR VGND sg13g2_decap_8
XFILLER_42_827 VPWR VGND sg13g2_decap_8
XFILLER_1_444 VPWR VGND sg13g2_decap_8
XFILLER_2_967 VPWR VGND sg13g2_decap_8
XFILLER_45_610 VPWR VGND sg13g2_decap_8
XFILLER_49_426 VPWR VGND sg13g2_decap_8
XFILLER_45_687 VPWR VGND sg13g2_decap_8
X_614_ _614_/Q _628_/CLK _614_/D fanout66/X VPWR VGND sg13g2_dfrbpq_1
X_545_ _545_/Q _557_/CLK _545_/D fanout97/X VPWR VGND sg13g2_dfrbpq_1
X_476_ _476_/Q _657_/CLK _476_/D fanout81/X VPWR VGND sg13g2_dfrbpq_1
XFILLER_5_750 VPWR VGND sg13g2_decap_8
Xdelaybuf_20_clk delaybuf_21_clk/A delaybuf_20_clk/A VPWR VGND sg13g2_buf_16
XFILLER_24_805 VPWR VGND sg13g2_decap_8
Xdelaybuf_11_clk delaybuf_12_clk/A delaybuf_11_clk/A VPWR VGND sg13g2_buf_16
XFILLER_15_805 VPWR VGND sg13g2_decap_8
XFILLER_30_819 VPWR VGND sg13g2_decap_8
XFILLER_42_635 VPWR VGND sg13g2_decap_8
X_330_ _495_/D _494_/Q _495_/Q _331_/S VPWR VGND sg13g2_mux2_1
X_261_ _266_/B _270_/S _617_/Q VPWR VGND sg13g2_nand2_1
XFILLER_6_558 VPWR VGND sg13g2_decap_8
XFILLER_2_764 VPWR VGND sg13g2_decap_8
XFILLER_9_0 VPWR VGND sg13g2_fill_1
XFILLER_45_451 VPWR VGND sg13g2_decap_8
XFILLER_14_882 VPWR VGND sg13g2_decap_8
XFILLER_21_819 VPWR VGND sg13g2_decap_4
X_528_ _528_/Q _541_/CLK _528_/D fanout71/X VPWR VGND sg13g2_dfrbpq_1
X_459_ _459_/Y _459_/A _459_/B VPWR VGND sg13g2_xnor2_1
XFILLER_12_1021 VPWR VGND sg13g2_decap_8
XFILLER_20_830 VPWR VGND sg13g2_fill_2
XFILLER_3_528 VPWR VGND sg13g2_decap_8
Xclkbuf_4_15_0_clk_regs clkbuf_4_15_0_clk_regs/X clkbuf_0_clk_regs/X VPWR VGND sg13g2_buf_8
XFILLER_4_1019 VPWR VGND sg13g2_decap_8
XFILLER_42_432 VPWR VGND sg13g2_fill_1
X_313_ _478_/D _477_/Q _478_/Q _323_/S VPWR VGND sg13g2_mux2_1
X_244_ _244_/X _637_/Q _248_/B VPWR VGND sg13g2_and2_1
XFILLER_11_896 VPWR VGND sg13g2_decap_8
XFILLER_7_856 VPWR VGND sg13g2_decap_8
XFILLER_2_561 VPWR VGND sg13g2_decap_8
XFILLER_38_749 VPWR VGND sg13g2_decap_8
XFILLER_45_292 VPWR VGND sg13g2_decap_8
XFILLER_46_782 VPWR VGND sg13g2_decap_8
XFILLER_29_749 VPWR VGND sg13g2_decap_8
XFILLER_7_108 VPWR VGND sg13g2_fill_1
XFILLER_4_837 VPWR VGND sg13g2_decap_8
XFILLER_43_763 VPWR VGND sg13g2_decap_8
XFILLER_47_535 VPWR VGND sg13g2_decap_8
X_227_ _231_/S _648_/Q _647_/Q VPWR VGND sg13g2_nand2_1
XFILLER_3_892 VPWR VGND sg13g2_decap_8
XFILLER_7_653 VPWR VGND sg13g2_decap_8
XFILLER_2_380 VPWR VGND sg13g2_decap_4
XFILLER_34_763 VPWR VGND sg13g2_decap_8
XFILLER_1_829 VPWR VGND sg13g2_decap_8
XFILLER_13_958 VPWR VGND sg13g2_decap_8
XFILLER_25_763 VPWR VGND sg13g2_decap_8
XFILLER_33_32 VPWR VGND sg13g2_fill_1
XFILLER_40_777 VPWR VGND sg13g2_decap_8
XFILLER_9_907 VPWR VGND sg13g2_decap_8
XFILLER_3_177 VPWR VGND sg13g2_fill_2
XFILLER_4_634 VPWR VGND sg13g2_decap_8
XFILLER_0_862 VPWR VGND sg13g2_decap_8
XFILLER_48_877 VPWR VGND sg13g2_decap_8
XFILLER_48_800 VPWR VGND sg13g2_decap_8
XFILLER_47_332 VPWR VGND sg13g2_decap_8
XFILLER_16_763 VPWR VGND sg13g2_decap_8
XFILLER_43_560 VPWR VGND sg13g2_decap_8
XFILLER_31_777 VPWR VGND sg13g2_decap_8
XFILLER_8_951 VPWR VGND sg13g2_decap_8
XFILLER_7_450 VPWR VGND sg13g2_decap_8
XFILLER_39_833 VPWR VGND sg13g2_decap_8
XFILLER_10_917 VPWR VGND sg13g2_decap_8
XFILLER_22_799 VPWR VGND sg13g2_decap_8
XFILLER_1_626 VPWR VGND sg13g2_decap_8
X_630_ _630_/Q _630_/CLK _630_/D fanout68/X VPWR VGND sg13g2_dfrbpq_1
Xclkbuf_1_1__f_clk clkload0/A clkbuf_0_clk/X VPWR VGND sg13g2_buf_16
XFILLER_49_619 VPWR VGND sg13g2_decap_8
XFILLER_44_302 VPWR VGND sg13g2_fill_1
XFILLER_44_335 VPWR VGND sg13g2_decap_8
X_561_ _561_/Q _561_/CLK _561_/D fanout94/X VPWR VGND sg13g2_dfrbpq_1
X_492_ _492_/Q _515_/CLK _492_/D fanout89/X VPWR VGND sg13g2_dfrbpq_1
XFILLER_5_932 VPWR VGND sg13g2_decap_8
XFILLER_48_674 VPWR VGND sg13g2_decap_8
XFILLER_47_195 VPWR VGND sg13g2_fill_1
XFILLER_42_806 VPWR VGND sg13g2_decap_8
XFILLER_1_423 VPWR VGND sg13g2_decap_8
XFILLER_2_946 VPWR VGND sg13g2_decap_8
XFILLER_30_66 VPWR VGND sg13g2_fill_2
XFILLER_7_1017 VPWR VGND sg13g2_decap_8
XFILLER_49_405 VPWR VGND sg13g2_decap_8
X_613_ _613_/Q _613_/CLK _613_/D fanout65/X VPWR VGND sg13g2_dfrbpq_1
XFILLER_7_1028 VPWR VGND sg13g2_fill_1
XFILLER_45_666 VPWR VGND sg13g2_decap_8
X_544_ _544_/Q _570_/CLK _544_/D fanout97/X VPWR VGND sg13g2_dfrbpq_1
X_475_ _475_/Q _659_/CLK _475_/D fanout81/X VPWR VGND sg13g2_dfrbpq_1
XFILLER_1_990 VPWR VGND sg13g2_decap_8
XFILLER_48_493 VPWR VGND sg13g2_decap_8
X_260_ _266_/A _647_/D _603_/Q VPWR VGND sg13g2_nand2_1
Xdelaybuf_4_clk delaybuf_5_clk/A delaybuf_4_clk/A VPWR VGND sg13g2_buf_16
XFILLER_6_537 VPWR VGND sg13g2_decap_8
XFILLER_2_743 VPWR VGND sg13g2_decap_8
XFILLER_45_430 VPWR VGND sg13g2_decap_8
X_527_ _527_/Q _656_/CLK _527_/D fanout71/X VPWR VGND sg13g2_dfrbpq_1
XFILLER_12_1000 VPWR VGND sg13g2_decap_8
XFILLER_14_861 VPWR VGND sg13g2_decap_8
X_458_ _458_/Y _460_/A _460_/B VPWR VGND sg13g2_xnor2_1
X_389_ _554_/D _553_/Q _554_/Q _405_/S VPWR VGND sg13g2_mux2_1
Xclkbuf_1_0__f__017__regs _257__99/A clkbuf_0__017__regs/X VPWR VGND sg13g2_buf_16
XFILLER_49_780 VPWR VGND sg13g2_decap_8
XFILLER_48_290 VPWR VGND sg13g2_decap_8
XFILLER_20_842 VPWR VGND sg13g2_decap_8
XFILLER_3_507 VPWR VGND sg13g2_decap_8
XFILLER_47_739 VPWR VGND sg13g2_decap_8
XFILLER_11_875 VPWR VGND sg13g2_decap_8
X_312_ _477_/D _476_/Q _477_/Q _323_/S VPWR VGND sg13g2_mux2_1
X_243_ _243_/X _636_/Q _248_/B VPWR VGND sg13g2_and2_1
XFILLER_2_540 VPWR VGND sg13g2_decap_8
XFILLER_7_835 VPWR VGND sg13g2_decap_8
XFILLER_45_271 VPWR VGND sg13g2_decap_8
XFILLER_46_761 VPWR VGND sg13g2_decap_8
XFILLER_44_709 VPWR VGND sg13g2_decap_8
XFILLER_3_326 VPWR VGND sg13g2_decap_4
XFILLER_4_816 VPWR VGND sg13g2_decap_8
XFILLER_47_514 VPWR VGND sg13g2_decap_4
XFILLER_16_967 VPWR VGND sg13g2_decap_8
XFILLER_43_742 VPWR VGND sg13g2_decap_8
X_226_ _226_/Y _653_/Q VPWR VGND sg13g2_inv_1
XFILLER_7_632 VPWR VGND sg13g2_decap_8
XFILLER_6_142 VPWR VGND sg13g2_fill_1
XFILLER_3_871 VPWR VGND sg13g2_decap_8
XFILLER_6_175 VPWR VGND sg13g2_fill_2
XFILLER_1_808 VPWR VGND sg13g2_decap_8
XFILLER_13_937 VPWR VGND sg13g2_decap_8
XFILLER_40_756 VPWR VGND sg13g2_decap_8
XFILLER_0_841 VPWR VGND sg13g2_decap_8
XFILLER_4_613 VPWR VGND sg13g2_decap_8
Xclkbuf_2_1__f_clk_delayed _444_/A clkbuf_0_clk_delayed/X VPWR VGND sg13g2_buf_16
XFILLER_48_856 VPWR VGND sg13g2_decap_8
XFILLER_47_388 VPWR VGND sg13g2_decap_8
XFILLER_47_311 VPWR VGND sg13g2_decap_8
XFILLER_31_756 VPWR VGND sg13g2_decap_8
XFILLER_8_930 VPWR VGND sg13g2_decap_8
XFILLER_7_495 VPWR VGND sg13g2_fill_1
XFILLER_39_812 VPWR VGND sg13g2_decap_8
XFILLER_0_1023 VPWR VGND sg13g2_decap_4
XFILLER_22_756 VPWR VGND sg13g2_decap_8
XFILLER_1_605 VPWR VGND sg13g2_decap_8
X_560_ _560_/Q _561_/CLK _560_/D fanout95/X VPWR VGND sg13g2_dfrbpq_1
XFILLER_45_848 VPWR VGND sg13g2_decap_4
X_491_ _491_/Q _515_/CLK _491_/D fanout89/X VPWR VGND sg13g2_dfrbpq_1
XFILLER_5_911 VPWR VGND sg13g2_decap_8
XFILLER_4_432 VPWR VGND sg13g2_decap_8
XFILLER_5_988 VPWR VGND sg13g2_decap_8
XFILLER_4_487 VPWR VGND sg13g2_decap_8
XFILLER_27_826 VPWR VGND sg13g2_fill_1
XFILLER_27_837 VPWR VGND sg13g2_decap_8
XFILLER_1_479 VPWR VGND sg13g2_decap_8
XFILLER_2_925 VPWR VGND sg13g2_decap_8
XFILLER_18_826 VPWR VGND sg13g2_decap_4
XFILLER_18_848 VPWR VGND sg13g2_decap_4
XFILLER_45_645 VPWR VGND sg13g2_decap_8
X_612_ _612_/Q _612_/CLK _612_/D fanout70/X VPWR VGND sg13g2_dfrbpq_1
X_543_ _543_/Q _557_/CLK _543_/D fanout97/X VPWR VGND sg13g2_dfrbpq_1
X_474_ _474_/Q _658_/CLK _474_/D fanout79/X VPWR VGND sg13g2_dfrbpq_1
XFILLER_5_785 VPWR VGND sg13g2_decap_8
XFILLER_48_472 VPWR VGND sg13g2_decap_8
XFILLER_2_722 VPWR VGND sg13g2_decap_8
XFILLER_2_799 VPWR VGND sg13g2_decap_8
XFILLER_14_840 VPWR VGND sg13g2_decap_8
XFILLER_45_486 VPWR VGND sg13g2_decap_8
X_526_ _526_/Q _626_/CLK _526_/D fanout70/X VPWR VGND sg13g2_dfrbpq_1
X_457_ _457_/Y _460_/A _459_/B VPWR VGND sg13g2_xnor2_1
X_388_ _553_/D _552_/Q _553_/Q _404_/S VPWR VGND sg13g2_mux2_1
XFILLER_5_582 VPWR VGND sg13g2_decap_8
XFILLER_47_718 VPWR VGND sg13g2_decap_8
XFILLER_11_854 VPWR VGND sg13g2_decap_8
XFILLER_42_467 VPWR VGND sg13g2_fill_2
X_311_ _476_/D _476_/Q input3/X _311_/S VPWR VGND sg13g2_mux2_1
X_242_ _242_/X _635_/Q _248_/B VPWR VGND sg13g2_and2_1
XFILLER_7_814 VPWR VGND sg13g2_decap_8
XFILLER_6_368 VPWR VGND sg13g2_decap_4
XFILLER_2_596 VPWR VGND sg13g2_decap_8
XFILLER_46_740 VPWR VGND sg13g2_decap_8
X_509_ _509_/Q _593_/CLK _509_/D fanout85/X VPWR VGND sg13g2_dfrbpq_1
XFILLER_6_891 VPWR VGND sg13g2_decap_8
XFILLER_37_784 VPWR VGND sg13g2_decap_8
XFILLER_47_98 VPWR VGND sg13g2_fill_1
XFILLER_28_784 VPWR VGND sg13g2_decap_8
XFILLER_43_721 VPWR VGND sg13g2_decap_8
X_225_ _225_/Y _652_/Q VPWR VGND sg13g2_inv_1
XFILLER_7_688 VPWR VGND sg13g2_decap_8
XFILLER_7_611 VPWR VGND sg13g2_decap_8
XFILLER_3_850 VPWR VGND sg13g2_decap_8
XFILLER_19_784 VPWR VGND sg13g2_decap_8
XFILLER_13_916 VPWR VGND sg13g2_decap_8
XFILLER_25_798 VPWR VGND sg13g2_decap_8
XFILLER_0_820 VPWR VGND sg13g2_decap_8
XFILLER_3_179 VPWR VGND sg13g2_fill_1
XFILLER_4_669 VPWR VGND sg13g2_decap_8
XFILLER_0_897 VPWR VGND sg13g2_decap_8
XFILLER_48_835 VPWR VGND sg13g2_decap_8
XFILLER_47_367 VPWR VGND sg13g2_decap_8
XFILLER_16_798 VPWR VGND sg13g2_decap_8
XFILLER_43_595 VPWR VGND sg13g2_fill_2
XFILLER_12_993 VPWR VGND sg13g2_decap_8
XFILLER_8_986 VPWR VGND sg13g2_decap_8
XFILLER_0_1002 VPWR VGND sg13g2_decap_8
XFILLER_45_827 VPWR VGND sg13g2_decap_8
X_490_ _490_/Q _511_/CLK _490_/D fanout88/X VPWR VGND sg13g2_dfrbpq_1
XFILLER_5_967 VPWR VGND sg13g2_decap_8
XFILLER_0_694 VPWR VGND sg13g2_decap_8
XFILLER_36_805 VPWR VGND sg13g2_decap_8
XFILLER_36_816 VPWR VGND sg13g2_decap_8
XFILLER_12_790 VPWR VGND sg13g2_decap_8
XFILLER_43_392 VPWR VGND sg13g2_decap_8
XFILLER_8_783 VPWR VGND sg13g2_decap_8
Xdelaybuf_23_clk delaybuf_23_clk/X delaybuf_23_clk/A VPWR VGND sg13g2_buf_16
XFILLER_7_282 VPWR VGND sg13g2_decap_8
XFILLER_27_805 VPWR VGND sg13g2_decap_8
XFILLER_10_749 VPWR VGND sg13g2_decap_8
XFILLER_2_904 VPWR VGND sg13g2_decap_8
XFILLER_1_458 VPWR VGND sg13g2_decap_8
Xclkbuf_4_1_0_clk_regs clkbuf_4_1_0_clk_regs/X clkbuf_0_clk_regs/X VPWR VGND sg13g2_buf_8
Xdelaybuf_14_clk delaybuf_15_clk/A delaybuf_14_clk/A VPWR VGND sg13g2_buf_16
XFILLER_18_805 VPWR VGND sg13g2_decap_8
XFILLER_45_624 VPWR VGND sg13g2_decap_8
X_611_ _611_/Q _612_/CLK _611_/D fanout67/X VPWR VGND sg13g2_dfrbpq_1
X_542_ _542_/Q _563_/CLK _542_/D fanout95/X VPWR VGND sg13g2_dfrbpq_1
X_473_ _473_/Q _659_/CLK _473_/D fanout79/X VPWR VGND sg13g2_dfrbpq_1
XFILLER_41_841 VPWR VGND sg13g2_decap_8
XFILLER_5_764 VPWR VGND sg13g2_decap_8
XFILLER_0_491 VPWR VGND sg13g2_decap_8
XFILLER_49_963 VPWR VGND sg13g2_decap_8
XFILLER_49_941 VPWR VGND sg13g2_decap_4
XFILLER_48_451 VPWR VGND sg13g2_decap_8
XFILLER_24_819 VPWR VGND sg13g2_decap_8
XFILLER_15_819 VPWR VGND sg13g2_decap_8
XFILLER_42_649 VPWR VGND sg13g2_decap_8
XFILLER_2_701 VPWR VGND sg13g2_decap_8
XFILLER_2_778 VPWR VGND sg13g2_decap_8
XFILLER_45_465 VPWR VGND sg13g2_decap_8
X_525_ _525_/Q _626_/CLK _525_/D fanout70/X VPWR VGND sg13g2_dfrbpq_1
X_456_ _456_/Y _456_/A _456_/B VPWR VGND sg13g2_xnor2_1
XFILLER_14_896 VPWR VGND sg13g2_decap_8
X_387_ _552_/D _551_/Q _552_/Q _404_/S VPWR VGND sg13g2_mux2_1
XFILLER_5_561 VPWR VGND sg13g2_decap_8
X_310_ _475_/D _475_/Q _310_/B VPWR VGND sg13g2_xnor2_1
XFILLER_11_833 VPWR VGND sg13g2_decap_8
X_241_ _241_/X _656_/Q _254_/B VPWR VGND sg13g2_and2_1
XFILLER_2_575 VPWR VGND sg13g2_decap_8
XFILLER_46_796 VPWR VGND sg13g2_decap_8
X_508_ _508_/Q _620_/CLK _508_/D fanout74/X VPWR VGND sg13g2_dfrbpq_1
X_439_ _439_/Y _444_/A _440_/B VPWR VGND sg13g2_xnor2_1
XFILLER_6_870 VPWR VGND sg13g2_decap_8
XFILLER_3_1011 VPWR VGND sg13g2_decap_8
XFILLER_37_763 VPWR VGND sg13g2_decap_8
XFILLER_22_36 VPWR VGND sg13g2_fill_2
XFILLER_3_306 VPWR VGND sg13g2_decap_4
XFILLER_28_763 VPWR VGND sg13g2_decap_8
XFILLER_43_700 VPWR VGND sg13g2_decap_8
XFILLER_47_549 VPWR VGND sg13g2_decap_8
XFILLER_43_777 VPWR VGND sg13g2_decap_4
X_224_ _224_/Y _651_/Q VPWR VGND sg13g2_inv_1
XFILLER_7_667 VPWR VGND sg13g2_decap_8
XFILLER_19_763 VPWR VGND sg13g2_decap_8
XFILLER_34_777 VPWR VGND sg13g2_decap_8
Xclkbuf_4_14_0_clk_regs clkbuf_4_14_0_clk_regs/X clkbuf_0_clk_regs/X VPWR VGND sg13g2_buf_8
XFILLER_46_593 VPWR VGND sg13g2_decap_8
XFILLER_25_777 VPWR VGND sg13g2_decap_8
XFILLER_4_648 VPWR VGND sg13g2_decap_8
XFILLER_0_876 VPWR VGND sg13g2_decap_8
XFILLER_48_814 VPWR VGND sg13g2_decap_8
XFILLER_16_777 VPWR VGND sg13g2_decap_8
XFILLER_47_346 VPWR VGND sg13g2_decap_8
XFILLER_12_972 VPWR VGND sg13g2_decap_8
XFILLER_43_574 VPWR VGND sg13g2_decap_8
XFILLER_8_965 VPWR VGND sg13g2_decap_8
XFILLER_7_464 VPWR VGND sg13g2_decap_8
XFILLER_39_847 VPWR VGND sg13g2_decap_4
Xclkbuf_leaf_2_clk _444_/B delaybuf_9_clk/X VPWR VGND sg13g2_buf_8
XFILLER_30_791 VPWR VGND sg13g2_decap_8
XFILLER_44_349 VPWR VGND sg13g2_decap_8
XFILLER_45_806 VPWR VGND sg13g2_decap_8
XFILLER_21_791 VPWR VGND sg13g2_decap_8
XFILLER_5_946 VPWR VGND sg13g2_decap_8
XFILLER_0_673 VPWR VGND sg13g2_decap_8
XFILLER_48_688 VPWR VGND sg13g2_decap_8
XFILLER_48_633 VPWR VGND sg13g2_decap_8
XFILLER_43_371 VPWR VGND sg13g2_decap_8
XFILLER_44_850 VPWR VGND sg13g2_fill_2
XFILLER_8_762 VPWR VGND sg13g2_decap_8
XFILLER_7_250 VPWR VGND sg13g2_fill_2
Xu_custom_cells.u_final_mux.SwitchMatrixMultiplexer_inv_inst _577_/Q _284_/B2 VPWR
+ _288_/B2 _280_/A1 VGND _575_/Q SwitchMatrixMultiplexer_inv
XFILLER_1_437 VPWR VGND sg13g2_decap_8
XFILLER_45_603 VPWR VGND sg13g2_decap_8
X_610_ _610_/Q _625_/CLK _610_/D fanout67/X VPWR VGND sg13g2_dfrbpq_1
XFILLER_49_419 VPWR VGND sg13g2_decap_8
XFILLER_41_820 VPWR VGND sg13g2_decap_8
X_541_ _541_/Q _541_/CLK _541_/D fanout71/X VPWR VGND sg13g2_dfrbpq_1
X_472_ _472_/Q _660_/CLK _472_/D fanout81/X VPWR VGND sg13g2_dfrbpq_1
Xdelaybuf_7_clk delaybuf_8_clk/A delaybuf_7_clk/A VPWR VGND sg13g2_buf_16
XFILLER_5_743 VPWR VGND sg13g2_decap_8
XFILLER_0_470 VPWR VGND sg13g2_decap_8
XFILLER_49_920 VPWR VGND sg13g2_decap_8
XFILLER_48_430 VPWR VGND sg13g2_decap_8
Xu_custom_cells.u_mux1.mux_inv_inst _286_/B2 VPWR VGND _574_/Q _573_/Q _572_/Q mux_inv
XFILLER_23_831 VPWR VGND sg13g2_decap_8
XFILLER_42_628 VPWR VGND sg13g2_decap_8
XFILLER_2_757 VPWR VGND sg13g2_decap_8
XFILLER_45_444 VPWR VGND sg13g2_decap_8
XFILLER_14_875 VPWR VGND sg13g2_decap_8
X_524_ _524_/Q _626_/CLK _524_/D fanout70/X VPWR VGND sg13g2_dfrbpq_1
X_455_ _455_/Y _456_/A _456_/B VPWR VGND sg13g2_xnor2_1
X_386_ _551_/D _550_/Q _551_/Q _398_/S VPWR VGND sg13g2_mux2_1
XFILLER_12_1014 VPWR VGND sg13g2_decap_8
XFILLER_5_540 VPWR VGND sg13g2_decap_8
XFILLER_49_794 VPWR VGND sg13g2_decap_8
XFILLER_20_812 VPWR VGND sg13g2_decap_8
XFILLER_11_812 VPWR VGND sg13g2_decap_8
XFILLER_42_425 VPWR VGND sg13g2_decap_8
X_240_ _240_/X _655_/Q _254_/B VPWR VGND sg13g2_and2_1
XFILLER_11_889 VPWR VGND sg13g2_decap_8
XFILLER_7_849 VPWR VGND sg13g2_decap_8
XFILLER_2_554 VPWR VGND sg13g2_decap_8
XFILLER_45_285 VPWR VGND sg13g2_decap_8
XFILLER_46_775 VPWR VGND sg13g2_decap_8
X_507_ _507_/Q _593_/CLK _507_/D fanout74/X VPWR VGND sg13g2_dfrbpq_1
X_438_ _438_/Y _444_/A _444_/B VPWR VGND sg13g2_xnor2_1
X_369_ _534_/D _533_/Q _534_/Q _407_/S VPWR VGND sg13g2_mux2_1
XFILLER_49_580 VPWR VGND sg13g2_decap_8
XFILLER_0_8 VPWR VGND sg13g2_fill_2
XFILLER_16_915 VPWR VGND sg13g2_fill_1
XFILLER_47_528 VPWR VGND sg13g2_decap_8
XFILLER_43_756 VPWR VGND sg13g2_decap_8
X_223_ _223_/Y _650_/Q VPWR VGND sg13g2_inv_1
XFILLER_7_646 VPWR VGND sg13g2_decap_8
XFILLER_2_373 VPWR VGND sg13g2_decap_8
XFILLER_2_384 VPWR VGND sg13g2_fill_2
XFILLER_3_885 VPWR VGND sg13g2_decap_8
XFILLER_34_756 VPWR VGND sg13g2_decap_8
XFILLER_46_572 VPWR VGND sg13g2_decap_8
XFILLER_25_756 VPWR VGND sg13g2_decap_8
XFILLER_4_627 VPWR VGND sg13g2_decap_8
XFILLER_0_855 VPWR VGND sg13g2_decap_8
Xu_clkbuf_analog_pin2.u_buf analog_pin2 _444_/A VPWR VGND sg13g2_buf_16
XFILLER_47_325 VPWR VGND sg13g2_decap_8
XFILLER_16_756 VPWR VGND sg13g2_decap_8
XFILLER_12_951 VPWR VGND sg13g2_decap_8
XFILLER_43_597 VPWR VGND sg13g2_fill_1
XFILLER_8_944 VPWR VGND sg13g2_decap_8
XFILLER_7_443 VPWR VGND sg13g2_decap_8
XFILLER_3_682 VPWR VGND sg13g2_decap_8
XFILLER_39_826 VPWR VGND sg13g2_decap_8
XFILLER_9_60 VPWR VGND sg13g2_fill_2
XFILLER_30_770 VPWR VGND sg13g2_decap_8
XFILLER_1_619 VPWR VGND sg13g2_decap_8
XFILLER_44_328 VPWR VGND sg13g2_decap_8
XFILLER_21_770 VPWR VGND sg13g2_decap_8
XFILLER_5_925 VPWR VGND sg13g2_decap_8
XFILLER_0_652 VPWR VGND sg13g2_decap_8
XFILLER_48_612 VPWR VGND sg13g2_decap_8
XFILLER_15_1012 VPWR VGND sg13g2_decap_8
XFILLER_4_991 VPWR VGND sg13g2_decap_8
XFILLER_15_0 VPWR VGND sg13g2_fill_1
Xu_custom_cells.u_latch0.latch_inst _284_/B2 _282_/B2 VGND VPWR _577_/Q latch
XFILLER_2_939 VPWR VGND sg13g2_decap_8
X_540_ _540_/Q _656_/CLK _540_/D fanout71/X VPWR VGND sg13g2_dfrbpq_1
XFILLER_26_840 VPWR VGND sg13g2_decap_8
XFILLER_26_851 VPWR VGND sg13g2_fill_1
XFILLER_45_659 VPWR VGND sg13g2_decap_8
X_471_ _471_/Q _660_/CLK _471_/D fanout82/X VPWR VGND sg13g2_dfrbpq_1
XFILLER_5_722 VPWR VGND sg13g2_decap_8
XFILLER_1_983 VPWR VGND sg13g2_decap_8
XFILLER_5_799 VPWR VGND sg13g2_decap_8
XFILLER_48_486 VPWR VGND sg13g2_decap_8
XFILLER_44_681 VPWR VGND sg13g2_decap_8
XFILLER_6_1010 VPWR VGND sg13g2_decap_8
XFILLER_23_810 VPWR VGND sg13g2_decap_8
XFILLER_2_736 VPWR VGND sg13g2_decap_8
XFILLER_45_423 VPWR VGND sg13g2_decap_8
X_523_ _523_/Q _626_/CLK _523_/D fanout69/X VPWR VGND sg13g2_dfrbpq_1
XFILLER_14_854 VPWR VGND sg13g2_decap_8
X_454_ _454_/Y _456_/A _456_/B VPWR VGND sg13g2_xnor2_1
X_385_ _550_/D _549_/Q _550_/Q _398_/S VPWR VGND sg13g2_mux2_1
XFILLER_5_596 VPWR VGND sg13g2_decap_8
XFILLER_1_780 VPWR VGND sg13g2_decap_8
XFILLER_49_773 VPWR VGND sg13g2_decap_8
XFILLER_11_868 VPWR VGND sg13g2_decap_8
XFILLER_2_533 VPWR VGND sg13g2_decap_8
XFILLER_7_828 VPWR VGND sg13g2_decap_8
X_506_ _506_/Q _541_/CLK _506_/D fanout85/X VPWR VGND sg13g2_dfrbpq_1
XFILLER_46_754 VPWR VGND sg13g2_decap_8
X_437_ _602_/D _291_/B _295_/Y _602_/Q VPWR VGND sg13g2_a21o_1
X_368_ _533_/D _532_/Q _533_/Q _407_/S VPWR VGND sg13g2_mux2_1
X_299_ _300_/B _218_/Y _297_/B _304_/A VPWR VGND sg13g2_o21ai_1
XFILLER_37_798 VPWR VGND sg13g2_decap_8
XFILLER_3_319 VPWR VGND sg13g2_decap_8
XFILLER_4_809 VPWR VGND sg13g2_decap_8
XFILLER_47_507 VPWR VGND sg13g2_decap_8
XFILLER_28_798 VPWR VGND sg13g2_decap_8
XFILLER_42_223 VPWR VGND sg13g2_fill_1
XFILLER_43_735 VPWR VGND sg13g2_decap_8
X_222_ _222_/Y _604_/Q VPWR VGND sg13g2_inv_1
XFILLER_7_625 VPWR VGND sg13g2_decap_8
XFILLER_2_352 VPWR VGND sg13g2_decap_8
XFILLER_3_864 VPWR VGND sg13g2_decap_8
XFILLER_6_157 VPWR VGND sg13g2_fill_1
XFILLER_46_551 VPWR VGND sg13g2_decap_8
XFILLER_19_798 VPWR VGND sg13g2_decap_8
XFILLER_6_691 VPWR VGND sg13g2_decap_8
XFILLER_40_749 VPWR VGND sg13g2_decap_8
XFILLER_4_606 VPWR VGND sg13g2_decap_8
XFILLER_0_834 VPWR VGND sg13g2_decap_8
XFILLER_48_849 VPWR VGND sg13g2_decap_8
XFILLER_47_304 VPWR VGND sg13g2_decap_8
XFILLER_12_930 VPWR VGND sg13g2_decap_8
XFILLER_31_749 VPWR VGND sg13g2_decap_8
XFILLER_8_923 VPWR VGND sg13g2_decap_8
XFILLER_7_422 VPWR VGND sg13g2_decap_8
XFILLER_39_805 VPWR VGND sg13g2_decap_8
XFILLER_3_661 VPWR VGND sg13g2_decap_8
XFILLER_0_1016 VPWR VGND sg13g2_decap_8
XFILLER_0_1027 VPWR VGND sg13g2_fill_2
XFILLER_46_392 VPWR VGND sg13g2_decap_8
XFILLER_22_749 VPWR VGND sg13g2_decap_8
Xdelaybuf_26_clk delaybuf_27_clk/A delaybuf_26_clk/A VPWR VGND sg13g2_buf_16
XFILLER_5_904 VPWR VGND sg13g2_decap_8
XFILLER_4_425 VPWR VGND sg13g2_decap_8
XFILLER_0_631 VPWR VGND sg13g2_decap_8
Xdelaybuf_17_clk delaybuf_18_clk/A clkbuf_0_clk/X VPWR VGND sg13g2_buf_16
XFILLER_8_797 VPWR VGND sg13g2_decap_8
XFILLER_7_296 VPWR VGND sg13g2_decap_8
XFILLER_4_970 VPWR VGND sg13g2_decap_8
XFILLER_27_819 VPWR VGND sg13g2_decap_8
XFILLER_35_841 VPWR VGND sg13g2_decap_8
XFILLER_47_690 VPWR VGND sg13g2_decap_8
XFILLER_30_27 VPWR VGND sg13g2_fill_2
Xu_clkbuf_analog_pin1.u_buf analog_pin1 _282_/A1 VPWR VGND sg13g2_buf_16
XFILLER_2_918 VPWR VGND sg13g2_decap_8
XFILLER_18_819 VPWR VGND sg13g2_decap_8
XFILLER_45_638 VPWR VGND sg13g2_decap_8
X_470_ _470_/Q _660_/CLK _470_/D fanout82/X VPWR VGND sg13g2_dfrbpq_1
XFILLER_5_778 VPWR VGND sg13g2_decap_8
XFILLER_5_701 VPWR VGND sg13g2_decap_8
XFILLER_1_962 VPWR VGND sg13g2_decap_8
XFILLER_49_977 VPWR VGND sg13g2_fill_1
XFILLER_32_800 VPWR VGND sg13g2_fill_1
XFILLER_32_811 VPWR VGND sg13g2_decap_4
XFILLER_44_660 VPWR VGND sg13g2_decap_8
X_599_ _599_/Q _630_/CLK _599_/D fanout65/X VPWR VGND sg13g2_dfrbpq_1
XFILLER_48_465 VPWR VGND sg13g2_decap_8
XFILLER_2_715 VPWR VGND sg13g2_decap_8
XFILLER_14_833 VPWR VGND sg13g2_decap_8
XFILLER_45_402 VPWR VGND sg13g2_decap_8
XFILLER_45_479 VPWR VGND sg13g2_decap_8
X_522_ _522_/Q _535_/CLK _522_/D fanout83/X VPWR VGND sg13g2_dfrbpq_1
X_453_ _453_/Y _459_/A _456_/B VPWR VGND sg13g2_xnor2_1
XFILLER_41_641 VPWR VGND sg13g2_decap_4
X_384_ _549_/D _548_/Q _549_/Q _397_/S VPWR VGND sg13g2_mux2_1
XFILLER_5_575 VPWR VGND sg13g2_decap_8
XFILLER_49_752 VPWR VGND sg13g2_decap_8
Xclkbuf_4_0_0_clk_regs clkbuf_4_0_0_clk_regs/X clkbuf_0_clk_regs/X VPWR VGND sg13g2_buf_8
XFILLER_11_847 VPWR VGND sg13g2_decap_8
XFILLER_7_807 VPWR VGND sg13g2_decap_8
XFILLER_2_512 VPWR VGND sg13g2_decap_8
XFILLER_2_589 VPWR VGND sg13g2_decap_8
XFILLER_46_733 VPWR VGND sg13g2_decap_8
X_505_ _505_/Q _505_/CLK _505_/D fanout87/X VPWR VGND sg13g2_dfrbpq_1
X_436_ _601_/D _600_/Q _601_/Q _436_/S VPWR VGND sg13g2_mux2_1
X_367_ _532_/D _531_/Q _532_/Q _407_/S VPWR VGND sg13g2_mux2_1
X_298_ _302_/B _469_/Q _470_/Q _311_/S VPWR VGND sg13g2_nand3_1
XFILLER_6_884 VPWR VGND sg13g2_decap_8
XFILLER_5_394 VPWR VGND sg13g2_decap_8
XFILLER_37_777 VPWR VGND sg13g2_decap_8
XFILLER_3_1025 VPWR VGND sg13g2_decap_4
XFILLER_28_777 VPWR VGND sg13g2_decap_8
XFILLER_43_714 VPWR VGND sg13g2_decap_8
X_221_ _647_/D _270_/S VPWR VGND sg13g2_inv_1
XFILLER_7_604 VPWR VGND sg13g2_decap_8
XFILLER_3_843 VPWR VGND sg13g2_decap_8
XFILLER_19_777 VPWR VGND sg13g2_decap_8
X_419_ _584_/D _583_/Q _584_/Q _436_/S VPWR VGND sg13g2_mux2_1
XFILLER_6_670 VPWR VGND sg13g2_decap_8
Xclkbuf_leaf_5_clk _452_/B delaybuf_16_clk/X VPWR VGND sg13g2_buf_8
XFILLER_13_909 VPWR VGND sg13g2_decap_8
XFILLER_33_791 VPWR VGND sg13g2_decap_8
Xclkbuf_5_19__f_clk_regs _612_/CLK clkbuf_4_9_0_clk_regs/X VPWR VGND sg13g2_buf_16
XFILLER_0_813 VPWR VGND sg13g2_decap_8
XFILLER_48_828 VPWR VGND sg13g2_decap_8
XFILLER_24_791 VPWR VGND sg13g2_decap_8
XFILLER_43_588 VPWR VGND sg13g2_decap_8
XFILLER_8_902 VPWR VGND sg13g2_decap_8
XFILLER_12_986 VPWR VGND sg13g2_decap_8
XFILLER_23_71 VPWR VGND sg13g2_fill_2
XFILLER_3_640 VPWR VGND sg13g2_decap_8
XFILLER_8_979 VPWR VGND sg13g2_decap_8
XFILLER_7_478 VPWR VGND sg13g2_decap_8
XFILLER_46_371 VPWR VGND sg13g2_decap_8
XFILLER_15_791 VPWR VGND sg13g2_decap_8
XFILLER_9_62 VPWR VGND sg13g2_fill_1
XFILLER_0_610 VPWR VGND sg13g2_decap_8
XFILLER_0_687 VPWR VGND sg13g2_decap_8
Xclkbuf_4_13_0_clk_regs clkbuf_4_13_0_clk_regs/X clkbuf_0_clk_regs/X VPWR VGND sg13g2_buf_8
XFILLER_48_647 VPWR VGND sg13g2_fill_2
XFILLER_12_783 VPWR VGND sg13g2_decap_8
XFILLER_43_385 VPWR VGND sg13g2_decap_8
XFILLER_8_776 VPWR VGND sg13g2_decap_8
XFILLER_44_149 VPWR VGND sg13g2_fill_1
XFILLER_45_617 VPWR VGND sg13g2_decap_8
XFILLER_41_834 VPWR VGND sg13g2_decap_8
XFILLER_5_757 VPWR VGND sg13g2_decap_8
XFILLER_0_484 VPWR VGND sg13g2_decap_8
XFILLER_1_941 VPWR VGND sg13g2_decap_8
XFILLER_49_956 VPWR VGND sg13g2_decap_8
XFILLER_49_945 VPWR VGND sg13g2_fill_1
XFILLER_49_934 VPWR VGND sg13g2_decap_8
XFILLER_48_444 VPWR VGND sg13g2_decap_8
X_598_ _598_/Q _630_/CLK _598_/D fanout65/X VPWR VGND sg13g2_dfrbpq_1
XANTENNA_1 ui_in[4] VPWR VGND sg13g2_antennanp
XFILLER_6_52 VPWR VGND sg13g2_fill_1
XFILLER_20_0 VPWR VGND sg13g2_fill_2
XFILLER_23_845 VPWR VGND sg13g2_decap_8
XFILLER_14_812 VPWR VGND sg13g2_decap_8
XFILLER_41_620 VPWR VGND sg13g2_decap_8
XFILLER_45_458 VPWR VGND sg13g2_decap_8
X_521_ _521_/Q _535_/CLK _521_/D fanout83/X VPWR VGND sg13g2_dfrbpq_1
X_452_ _452_/Y _459_/A _452_/B VPWR VGND sg13g2_xnor2_1
X_383_ _548_/D _547_/Q _548_/Q _397_/S VPWR VGND sg13g2_mux2_1
XFILLER_12_1028 VPWR VGND sg13g2_fill_1
XFILLER_14_889 VPWR VGND sg13g2_decap_8
Xu_clkbuf_analog_pin0.u_buf analog_pin0 _280_/A0 VPWR VGND sg13g2_buf_16
XFILLER_5_554 VPWR VGND sg13g2_decap_8
XFILLER_49_731 VPWR VGND sg13g2_decap_8
XFILLER_20_826 VPWR VGND sg13g2_decap_4
XFILLER_9_893 VPWR VGND sg13g2_decap_8
XFILLER_11_826 VPWR VGND sg13g2_decap_8
XFILLER_2_568 VPWR VGND sg13g2_decap_8
XFILLER_46_712 VPWR VGND sg13g2_decap_8
XFILLER_45_299 VPWR VGND sg13g2_decap_8
X_504_ _504_/Q _505_/CLK _504_/D fanout87/X VPWR VGND sg13g2_dfrbpq_1
X_435_ _600_/D _599_/Q _600_/Q _436_/S VPWR VGND sg13g2_mux2_1
X_366_ _531_/D _530_/Q _531_/Q _366_/S VPWR VGND sg13g2_mux2_1
XFILLER_46_789 VPWR VGND sg13g2_decap_8
X_297_ _469_/D _469_/Q _297_/B VPWR VGND sg13g2_xnor2_1
XFILLER_6_863 VPWR VGND sg13g2_decap_8
XFILLER_3_42 VPWR VGND sg13g2_fill_1
XFILLER_37_756 VPWR VGND sg13g2_decap_8
XFILLER_3_1004 VPWR VGND sg13g2_decap_8
XFILLER_49_594 VPWR VGND sg13g2_decap_4
Xclkbuf_5_18__f_clk_regs _626_/CLK clkbuf_4_9_0_clk_regs/X VPWR VGND sg13g2_buf_16
XFILLER_28_756 VPWR VGND sg13g2_decap_8
X_220_ _220_/Y _472_/Q VPWR VGND sg13g2_inv_1
XFILLER_3_822 VPWR VGND sg13g2_decap_8
XFILLER_3_899 VPWR VGND sg13g2_decap_8
XFILLER_19_756 VPWR VGND sg13g2_decap_8
XFILLER_46_586 VPWR VGND sg13g2_decap_8
XFILLER_15_973 VPWR VGND sg13g2_decap_4
XFILLER_41_291 VPWR VGND sg13g2_fill_2
X_418_ _583_/D _609_/D _583_/Q _432_/S VPWR VGND sg13g2_mux2_1
X_349_ _514_/D _513_/Q _514_/Q _350_/S VPWR VGND sg13g2_mux2_1
XFILLER_49_391 VPWR VGND sg13g2_decap_8
XFILLER_33_770 VPWR VGND sg13g2_decap_8
XFILLER_0_869 VPWR VGND sg13g2_decap_8
XFILLER_48_807 VPWR VGND sg13g2_decap_8
XFILLER_47_339 VPWR VGND sg13g2_decap_8
XFILLER_12_965 VPWR VGND sg13g2_decap_8
XFILLER_24_770 VPWR VGND sg13g2_decap_8
XFILLER_43_567 VPWR VGND sg13g2_decap_8
XFILLER_2_140 VPWR VGND sg13g2_fill_1
XFILLER_8_958 VPWR VGND sg13g2_decap_8
XFILLER_7_457 VPWR VGND sg13g2_decap_8
XFILLER_48_1027 VPWR VGND sg13g2_fill_2
XFILLER_0_10 VPWR VGND sg13g2_fill_1
XFILLER_3_696 VPWR VGND sg13g2_decap_8
XFILLER_47_851 VPWR VGND sg13g2_fill_1
XFILLER_15_770 VPWR VGND sg13g2_decap_8
XFILLER_46_350 VPWR VGND sg13g2_decap_8
XFILLER_30_784 VPWR VGND sg13g2_decap_8
XFILLER_38_840 VPWR VGND sg13g2_decap_8
XFILLER_38_851 VPWR VGND sg13g2_fill_1
XFILLER_21_784 VPWR VGND sg13g2_decap_8
XFILLER_5_939 VPWR VGND sg13g2_decap_8
XFILLER_0_666 VPWR VGND sg13g2_decap_8
XFILLER_48_626 VPWR VGND sg13g2_decap_8
XFILLER_44_843 VPWR VGND sg13g2_decap_8
XFILLER_15_1026 VPWR VGND sg13g2_fill_2
XFILLER_3_493 VPWR VGND sg13g2_decap_8
XFILLER_41_813 VPWR VGND sg13g2_decap_8
XFILLER_1_920 VPWR VGND sg13g2_decap_8
Xclkbuf_regs_1_clk clkbuf_regs_1_clk/X _256_/Y VPWR VGND sg13g2_buf_16
XFILLER_5_736 VPWR VGND sg13g2_decap_8
XFILLER_4_213 VPWR VGND sg13g2_fill_1
XFILLER_0_463 VPWR VGND sg13g2_decap_8
XFILLER_1_997 VPWR VGND sg13g2_decap_8
XFILLER_49_913 VPWR VGND sg13g2_decap_8
XFILLER_48_423 VPWR VGND sg13g2_decap_8
XFILLER_44_695 VPWR VGND sg13g2_decap_8
X_597_ _626_/D _625_/CLK _597_/D fanout66/X VPWR VGND sg13g2_dfrbpq_1
XANTENNA_2 ui_in[7] VPWR VGND sg13g2_antennanp
XFILLER_6_1024 VPWR VGND sg13g2_decap_4
XFILLER_23_824 VPWR VGND sg13g2_decap_8
XFILLER_41_39 VPWR VGND sg13g2_fill_2
X_520_ _520_/Q _535_/CLK _520_/D fanout83/X VPWR VGND sg13g2_dfrbpq_1
XFILLER_14_868 VPWR VGND sg13g2_decap_8
XFILLER_45_437 VPWR VGND sg13g2_decap_8
X_451_ _451_/Y _456_/A _452_/B VPWR VGND sg13g2_xnor2_1
X_382_ _547_/D _546_/Q _547_/Q _397_/S VPWR VGND sg13g2_mux2_1
XFILLER_12_1007 VPWR VGND sg13g2_decap_8
XFILLER_31_72 VPWR VGND sg13g2_fill_1
XFILLER_5_533 VPWR VGND sg13g2_decap_8
XFILLER_1_794 VPWR VGND sg13g2_decap_8
XFILLER_49_710 VPWR VGND sg13g2_decap_8
X_649_ _649_/Q _657_/CLK _649_/D fanout78/X VPWR VGND sg13g2_dfrbpq_1
XFILLER_49_787 VPWR VGND sg13g2_decap_8
XFILLER_48_297 VPWR VGND sg13g2_decap_8
XFILLER_20_805 VPWR VGND sg13g2_decap_8
XFILLER_20_849 VPWR VGND sg13g2_fill_2
Xclkbuf_5_17__f_clk_regs _613_/CLK clkbuf_4_8_0_clk_regs/X VPWR VGND sg13g2_buf_16
XFILLER_9_872 VPWR VGND sg13g2_decap_8
Xu_custom_cells.u_mux0.mux_inst VGND VPWR _288_/B2 _570_/Q _574_/Q _571_/Q mux
XFILLER_11_805 VPWR VGND sg13g2_decap_8
XFILLER_2_547 VPWR VGND sg13g2_decap_8
XFILLER_45_278 VPWR VGND sg13g2_decap_8
X_503_ _503_/Q _511_/CLK _503_/D fanout87/X VPWR VGND sg13g2_dfrbpq_1
XFILLER_46_768 VPWR VGND sg13g2_decap_8
X_434_ _599_/D _598_/Q _599_/Q _436_/S VPWR VGND sg13g2_mux2_1
X_365_ _530_/D _529_/Q _530_/Q _366_/S VPWR VGND sg13g2_mux2_1
X_296_ _297_/B _295_/A _295_/B _311_/S VPWR VGND sg13g2_o21ai_1
XFILLER_10_882 VPWR VGND sg13g2_decap_8
XFILLER_6_842 VPWR VGND sg13g2_decap_8
XFILLER_1_591 VPWR VGND sg13g2_decap_8
XFILLER_49_573 VPWR VGND sg13g2_decap_8
XFILLER_16_908 VPWR VGND sg13g2_decap_8
XFILLER_43_749 VPWR VGND sg13g2_decap_8
XFILLER_3_801 VPWR VGND sg13g2_decap_8
XFILLER_7_639 VPWR VGND sg13g2_decap_8
XFILLER_2_333 VPWR VGND sg13g2_fill_2
XFILLER_2_366 VPWR VGND sg13g2_decap_8
XFILLER_3_878 VPWR VGND sg13g2_decap_8
XFILLER_46_510 VPWR VGND sg13g2_decap_8
XFILLER_15_930 VPWR VGND sg13g2_decap_4
XFILLER_34_749 VPWR VGND sg13g2_decap_8
XFILLER_46_565 VPWR VGND sg13g2_decap_8
XFILLER_42_782 VPWR VGND sg13g2_decap_8
X_417_ _582_/D _581_/Q _609_/D _429_/S VPWR VGND sg13g2_mux2_1
X_348_ _513_/D _512_/Q _513_/Q _350_/S VPWR VGND sg13g2_mux2_1
X_279_ _279_/Y _281_/A _279_/B VPWR VGND sg13g2_nor2_1
XFILLER_49_370 VPWR VGND sg13g2_decap_8
XFILLER_25_749 VPWR VGND sg13g2_decap_8
Xdelaybuf_29_clk delaybuf_29_clk/X delaybuf_29_clk/A VPWR VGND sg13g2_buf_16
XFILLER_0_848 VPWR VGND sg13g2_decap_8
XFILLER_47_318 VPWR VGND sg13g2_decap_8
XFILLER_16_749 VPWR VGND sg13g2_decap_8
XFILLER_12_944 VPWR VGND sg13g2_decap_8
XFILLER_8_937 VPWR VGND sg13g2_decap_8
XFILLER_7_436 VPWR VGND sg13g2_decap_8
XFILLER_3_675 VPWR VGND sg13g2_decap_8
XFILLER_39_819 VPWR VGND sg13g2_decap_8
Xu_custom_cells.u_latmux.SwitchMatrixMultiplexer_inst _576_/Q VGND VPWR _288_/B2 _286_/B2
+ _282_/B2 _575_/Q SwitchMatrixMultiplexer
XFILLER_47_830 VPWR VGND sg13g2_decap_8
XFILLER_47_896 VPWR VGND sg13g2_decap_8
XFILLER_30_763 VPWR VGND sg13g2_decap_8
XFILLER_43_0 VPWR VGND sg13g2_fill_1
XFILLER_21_763 VPWR VGND sg13g2_decap_8
XFILLER_5_918 VPWR VGND sg13g2_decap_8
XFILLER_4_439 VPWR VGND sg13g2_fill_1
XFILLER_0_645 VPWR VGND sg13g2_decap_8
XFILLER_48_605 VPWR VGND sg13g2_decap_8
XFILLER_47_159 VPWR VGND sg13g2_fill_1
XFILLER_44_822 VPWR VGND sg13g2_decap_8
XFILLER_15_1005 VPWR VGND sg13g2_decap_8
XFILLER_3_450 VPWR VGND sg13g2_fill_2
XFILLER_4_984 VPWR VGND sg13g2_decap_8
XFILLER_26_833 VPWR VGND sg13g2_decap_8
XFILLER_5_715 VPWR VGND sg13g2_decap_8
XFILLER_0_442 VPWR VGND sg13g2_decap_8
XFILLER_1_976 VPWR VGND sg13g2_decap_8
XFILLER_48_402 VPWR VGND sg13g2_decap_8
XFILLER_17_833 VPWR VGND sg13g2_decap_4
XFILLER_48_479 VPWR VGND sg13g2_decap_8
XFILLER_44_674 VPWR VGND sg13g2_decap_8
X_596_ _596_/Q _625_/CLK _596_/D fanout66/X VPWR VGND sg13g2_dfrbpq_1
Xclkbuf_5_16__f_clk_regs _625_/CLK clkbuf_4_8_0_clk_regs/X VPWR VGND sg13g2_buf_16
XANTENNA_3 uio_in[0] VPWR VGND sg13g2_antennanp
XFILLER_6_1003 VPWR VGND sg13g2_decap_8
XFILLER_4_781 VPWR VGND sg13g2_decap_8
XFILLER_2_729 VPWR VGND sg13g2_decap_8
XFILLER_45_416 VPWR VGND sg13g2_decap_8
XFILLER_14_847 VPWR VGND sg13g2_decap_8
X_450_ _450_/Y _456_/A _452_/B VPWR VGND sg13g2_xnor2_1
X_381_ _546_/D _545_/Q _546_/Q _397_/S VPWR VGND sg13g2_mux2_1
XFILLER_5_589 VPWR VGND sg13g2_decap_8
XFILLER_0_283 VPWR VGND sg13g2_fill_2
XFILLER_1_773 VPWR VGND sg13g2_decap_8
XFILLER_49_766 VPWR VGND sg13g2_decap_8
X_648_ _648_/Q _648_/CLK _648_/D fanout77/X VPWR VGND sg13g2_dfrbpq_1
X_579_ _579_/Q _593_/CLK _579_/D fanout85/X VPWR VGND sg13g2_dfrbpq_1
XFILLER_9_851 VPWR VGND sg13g2_decap_8
XFILLER_2_526 VPWR VGND sg13g2_decap_8
Xdelaybuf_0_clk delaybuf_0_clk/X u_delay_line/clk VPWR VGND sg13g2_buf_16
X_502_ _502_/Q _511_/CLK _502_/D fanout87/X VPWR VGND sg13g2_dfrbpq_1
X_433_ _598_/D _626_/D _598_/Q _436_/S VPWR VGND sg13g2_mux2_1
XFILLER_46_747 VPWR VGND sg13g2_decap_8
XFILLER_10_861 VPWR VGND sg13g2_decap_8
X_364_ _529_/D _528_/Q _529_/Q _376_/S VPWR VGND sg13g2_mux2_1
X_295_ _295_/Y _295_/A _295_/B VPWR VGND sg13g2_nor2_1
XFILLER_6_821 VPWR VGND sg13g2_decap_8
XFILLER_6_898 VPWR VGND sg13g2_decap_8
XFILLER_5_342 VPWR VGND sg13g2_decap_4
XFILLER_5_320 VPWR VGND sg13g2_decap_4
XFILLER_1_570 VPWR VGND sg13g2_decap_8
XFILLER_49_552 VPWR VGND sg13g2_decap_8
XFILLER_36_791 VPWR VGND sg13g2_decap_8
XFILLER_43_728 VPWR VGND sg13g2_decap_8
XFILLER_7_618 VPWR VGND sg13g2_decap_8
XFILLER_2_323 VPWR VGND sg13g2_fill_1
XFILLER_2_345 VPWR VGND sg13g2_decap_8
XFILLER_3_857 VPWR VGND sg13g2_decap_8
XFILLER_27_791 VPWR VGND sg13g2_decap_8
XFILLER_42_761 VPWR VGND sg13g2_decap_8
X_416_ _581_/D _580_/Q _581_/Q _416_/S VPWR VGND sg13g2_mux2_1
XFILLER_46_544 VPWR VGND sg13g2_decap_8
X_347_ _512_/D _511_/Q _512_/Q _350_/S VPWR VGND sg13g2_mux2_1
X_278_ _278_/X _278_/A0 _626_/Q _278_/S VPWR VGND sg13g2_mux2_1
XFILLER_2_890 VPWR VGND sg13g2_decap_8
XFILLER_6_684 VPWR VGND sg13g2_decap_8
XFILLER_18_791 VPWR VGND sg13g2_decap_8
XFILLER_0_827 VPWR VGND sg13g2_decap_8
XFILLER_12_923 VPWR VGND sg13g2_decap_8
XFILLER_43_503 VPWR VGND sg13g2_fill_1
XFILLER_8_916 VPWR VGND sg13g2_decap_8
XFILLER_7_415 VPWR VGND sg13g2_decap_8
XFILLER_3_0 VPWR VGND sg13g2_fill_1
XFILLER_3_654 VPWR VGND sg13g2_decap_8
XFILLER_0_1009 VPWR VGND sg13g2_decap_8
XFILLER_48_60 VPWR VGND sg13g2_fill_2
XFILLER_46_385 VPWR VGND sg13g2_decap_8
XFILLER_7_982 VPWR VGND sg13g2_decap_8
XFILLER_9_1012 VPWR VGND sg13g2_decap_8
XFILLER_0_624 VPWR VGND sg13g2_decap_8
XFILLER_4_418 VPWR VGND sg13g2_decap_8
XFILLER_44_801 VPWR VGND sg13g2_decap_8
XFILLER_12_753 VPWR VGND sg13g2_fill_2
XFILLER_15_1028 VPWR VGND sg13g2_fill_1
XFILLER_43_333 VPWR VGND sg13g2_fill_2
XFILLER_43_399 VPWR VGND sg13g2_decap_8
Xclkbuf_5_15__f_clk_regs _557_/CLK clkbuf_4_7_0_clk_regs/X VPWR VGND sg13g2_buf_16
XFILLER_12_797 VPWR VGND sg13g2_decap_8
XFILLER_7_289 VPWR VGND sg13g2_decap_8
XFILLER_4_963 VPWR VGND sg13g2_decap_8
XFILLER_35_834 VPWR VGND sg13g2_decap_8
XFILLER_47_683 VPWR VGND sg13g2_decap_8
XFILLER_47_650 VPWR VGND sg13g2_fill_1
XFILLER_26_812 VPWR VGND sg13g2_decap_8
XFILLER_41_848 VPWR VGND sg13g2_decap_4
XFILLER_0_421 VPWR VGND sg13g2_decap_8
XFILLER_0_498 VPWR VGND sg13g2_decap_8
XFILLER_1_955 VPWR VGND sg13g2_decap_8
XFILLER_17_812 VPWR VGND sg13g2_decap_8
XFILLER_43_141 VPWR VGND sg13g2_fill_2
XFILLER_44_653 VPWR VGND sg13g2_decap_8
X_595_ _624_/D _613_/CLK _595_/D fanout69/X VPWR VGND sg13g2_dfrbpq_1
XFILLER_48_458 VPWR VGND sg13g2_decap_8
XANTENNA_4 _617_/D VPWR VGND sg13g2_antennanp
XFILLER_4_760 VPWR VGND sg13g2_decap_8
Xclkbuf_4_12_0_clk_regs clkbuf_4_12_0_clk_regs/X clkbuf_0_clk_regs/X VPWR VGND sg13g2_buf_8
XFILLER_2_708 VPWR VGND sg13g2_decap_8
XFILLER_14_826 VPWR VGND sg13g2_decap_8
XFILLER_41_634 VPWR VGND sg13g2_decap_8
XFILLER_41_645 VPWR VGND sg13g2_fill_1
X_380_ _545_/D _544_/Q _545_/Q _405_/S VPWR VGND sg13g2_mux2_1
Xoutput30 uo_out[0] _280_/X VPWR VGND sg13g2_buf_1
XFILLER_5_568 VPWR VGND sg13g2_decap_8
XFILLER_1_752 VPWR VGND sg13g2_decap_8
XFILLER_49_745 VPWR VGND sg13g2_decap_8
XFILLER_44_483 VPWR VGND sg13g2_fill_1
X_578_ _578_/Q _593_/CLK _578_/D fanout74/X VPWR VGND sg13g2_dfrbpq_1
X_647_ _647_/Q _647_/CLK _647_/D fanout77/X VPWR VGND sg13g2_dfrbpq_1
XFILLER_13_881 VPWR VGND sg13g2_decap_8
XFILLER_9_830 VPWR VGND sg13g2_decap_8
.ends
