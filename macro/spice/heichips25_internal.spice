* NGSPICE file created from heichips25_internal.ext - technology: ihp-sg13g2

* Black-box entry subcircuit for sg13g2_decap_8 abstract view
.subckt sg13g2_decap_8 VDD VSS
.ends

* Black-box entry subcircuit for sg13g2_dfrbpq_1 abstract view
.subckt sg13g2_dfrbpq_1 Q CLK D RESET_B VDD VSS
.ends

* Black-box entry subcircuit for sg13g2_mux2_1 abstract view
.subckt sg13g2_mux2_1 X A0 A1 S VDD VSS
.ends

* Black-box entry subcircuit for sg13g2_nand4_1 abstract view
.subckt sg13g2_nand4_1 Y A B C D VDD VSS
.ends

* Black-box entry subcircuit for sg13g2_fill_1 abstract view
.subckt sg13g2_fill_1 VDD VSS
.ends

* Black-box entry subcircuit for sg13g2_fill_2 abstract view
.subckt sg13g2_fill_2 VDD VSS
.ends

* Black-box entry subcircuit for sg13g2_buf_16 abstract view
.subckt sg13g2_buf_16 X A VDD VSS
.ends

* Black-box entry subcircuit for sg13g2_buf_1 abstract view
.subckt sg13g2_buf_1 X A VDD VSS
.ends

* Black-box entry subcircuit for sg13g2_nand3b_1 abstract view
.subckt sg13g2_nand3b_1 Y A_N B C VDD VSS
.ends

* Black-box entry subcircuit for sg13g2_and2_1 abstract view
.subckt sg13g2_and2_1 X A B VDD VSS
.ends

* Black-box entry subcircuit for sg13g2_decap_4 abstract view
.subckt sg13g2_decap_4 VDD VSS
.ends

* Black-box entry subcircuit for sg13g2_nor2_1 abstract view
.subckt sg13g2_nor2_1 Y A B VDD VSS
.ends

* Black-box entry subcircuit for sg13g2_buf_8 abstract view
.subckt sg13g2_buf_8 X A VDD VSS
.ends

* Black-box entry subcircuit for sg13g2_nand2b_1 abstract view
.subckt sg13g2_nand2b_1 Y A_N B VDD VSS
.ends

* Black-box entry subcircuit for sg13g2_a21oi_1 abstract view
.subckt sg13g2_a21oi_1 Y A1 A2 B1 VDD VSS
.ends

* Black-box entry subcircuit for sg13g2_nor2b_1 abstract view
.subckt sg13g2_nor2b_1 Y A B_N VDD VSS
.ends

* Black-box entry subcircuit for sg13g2_xnor2_1 abstract view
.subckt sg13g2_xnor2_1 Y A B VDD VSS
.ends

* Black-box entry subcircuit for delay_line abstract view
.subckt delay_line VDD VSS clk clk_delayed reset sel[0] sel[1] sel[2] sel[3] trim[0]
+ trim[10] trim[11] trim[12] trim[13] trim[14] trim[15] trim[16] trim[17] trim[18]
+ trim[19] trim[1] trim[20] trim[21] trim[22] trim[23] trim[2] trim[3] trim[4] trim[5]
+ trim[6] trim[7] trim[8] trim[9]
.ends

* Black-box entry subcircuit for sg13g2_dlygate4sd3_1 abstract view
.subckt sg13g2_dlygate4sd3_1 X A VDD VSS
.ends

* Black-box entry subcircuit for sg13g2_inv_4 abstract view
.subckt sg13g2_inv_4 Y A VDD VSS
.ends

* Black-box entry subcircuit for sg13g2_nand2_1 abstract view
.subckt sg13g2_nand2_1 Y A B VDD VSS
.ends

* Black-box entry subcircuit for sg13g2_inv_1 abstract view
.subckt sg13g2_inv_1 Y A VDD VSS
.ends

* Black-box entry subcircuit for sg13g2_xor2_1 abstract view
.subckt sg13g2_xor2_1 X A B VDD VSS
.ends

* Black-box entry subcircuit for sg13g2_nor3_1 abstract view
.subckt sg13g2_nor3_1 Y A B C VDD VSS
.ends

* Black-box entry subcircuit for sg13g2_nand3_1 abstract view
.subckt sg13g2_nand3_1 Y A B C VDD VSS
.ends

* Black-box entry subcircuit for sg13g2_o21ai_1 abstract view
.subckt sg13g2_o21ai_1 Y A1 A2 B1 VDD VSS
.ends

* Black-box entry subcircuit for sg13g2_a22oi_1 abstract view
.subckt sg13g2_a22oi_1 Y A1 A2 B1 B2 VDD VSS
.ends

* Black-box entry subcircuit for sg13g2_inv_2 abstract view
.subckt sg13g2_inv_2 Y A VDD VSS
.ends

* Black-box entry subcircuit for sg13g2_or2_1 abstract view
.subckt sg13g2_or2_1 X A B VDD VSS
.ends

* Black-box entry subcircuit for sg13g2_mux4_1 abstract view
.subckt sg13g2_mux4_1 X A0 A1 A2 A3 S0 S1 VDD VSS
.ends

* Black-box entry subcircuit for multimode_dll abstract view
.subckt multimode_dll VDD VSS bias clk0_out clk0_phase_sel[0] clk0_phase_sel[1] clk0_phase_sel[2]
+ clk0_phase_sel[3] clk0_phase_sel[4] clk1_out clk1_phase_sel[0] clk1_phase_sel[1]
+ clk1_phase_sel[2] clk1_phase_sel[3] clk1_phase_sel[4] clk2_out clk2_phase_sel[0]
+ clk2_phase_sel[1] clk2_phase_sel[2] clk2_phase_sel[3] clk2_phase_sel[4] dco enable
+ ext_trim[0] ext_trim[10] ext_trim[11] ext_trim[12] ext_trim[13] ext_trim[14] ext_trim[15]
+ ext_trim[16] ext_trim[17] ext_trim[18] ext_trim[19] ext_trim[1] ext_trim[20] ext_trim[21]
+ ext_trim[22] ext_trim[23] ext_trim[24] ext_trim[25] ext_trim[2] ext_trim[3] ext_trim[4]
+ ext_trim[5] ext_trim[6] ext_trim[7] ext_trim[8] ext_trim[9] f_clk0_divider[0] f_clk0_divider[1]
+ f_clk0_divider[2] f_clk0_divider[3] f_clk0_divider[4] f_clk1_divider[0] f_clk1_divider[1]
+ f_clk1_divider[2] f_clk1_divider[3] f_clk1_divider[4] f_clk2_divider[0] f_clk2_divider[1]
+ f_clk2_divider[2] f_clk2_divider[3] f_clk2_divider[4] f_osc_multiply_factor[0] f_osc_multiply_factor[1]
+ f_osc_multiply_factor[2] f_osc_multiply_factor[3] f_osc_multiply_factor[4] mode_xor[0]
+ mode_xor[1] mode_xor[2] osc osc_out resetb stable
.ends

* Black-box entry subcircuit for SwitchMatrixMultiplexer_inv abstract view
.subckt SwitchMatrixMultiplexer_inv D A VDD B X VSS SEL
.ends

* Black-box entry subcircuit for mux_inv abstract view
.subckt mux_inv X VDD VSS SEL B A
.ends

* Black-box entry subcircuit for latch abstract view
.subckt latch Q D VSS VDD GATE
.ends

* Black-box entry subcircuit for sg13g2_a21o_1 abstract view
.subckt sg13g2_a21o_1 X A1 A2 B1 VDD VSS
.ends

* Black-box entry subcircuit for mux abstract view
.subckt mux VSS VDD X A SEL B
.ends

* Black-box entry subcircuit for SwitchMatrixMultiplexer abstract view
.subckt SwitchMatrixMultiplexer D VSS VDD A B X SEL
.ends

.subckt heichips25_internal VGND VPWR analog_pin0 analog_pin1 analog_pin2 clk ena
+ rst_n ui_in[0] ui_in[1] ui_in[2] ui_in[3] ui_in[4] ui_in[5] ui_in[6] ui_in[7] uio_in[0]
+ uio_in[1] uio_in[2] uio_in[3] uio_in[4] uio_in[5] uio_in[6] uio_in[7] uio_oe[0]
+ uio_oe[1] uio_oe[2] uio_oe[3] uio_oe[4] uio_oe[5] uio_oe[6] uio_oe[7] uio_out[0]
+ uio_out[1] uio_out[2] uio_out[3] uio_out[4] uio_out[5] uio_out[6] uio_out[7] uo_out[0]
+ uo_out[1] uo_out[2] uo_out[3] uo_out[4] uo_out[5] uo_out[6] uo_out[7]
XFILLER_46_704 VPWR VGND sg13g2_decap_8
XFILLER_45_269 VPWR VGND sg13g2_decap_8
X_501_ _501_/Q _607_/CLK _501_/D fanout86/X VPWR VGND sg13g2_dfrbpq_1
X_432_ _597_/D _596_/Q _626_/D _432_/S VPWR VGND sg13g2_mux2_1
XFILLER_10_851 VPWR VGND sg13g2_decap_8
X_363_ _528_/D _527_/Q _528_/Q _374_/S VPWR VGND sg13g2_mux2_1
X_294_ _295_/B _469_/Q _471_/Q _472_/Q _475_/Q VPWR VGND sg13g2_nand4_1
XFILLER_6_866 VPWR VGND sg13g2_decap_8
XFILLER_5_387 VPWR VGND sg13g2_decap_8
XFILLER_3_1018 VPWR VGND sg13g2_decap_8
XFILLER_49_553 VPWR VGND sg13g2_decap_8
XFILLER_36_770 VPWR VGND sg13g2_decap_8
XFILLER_36_781 VPWR VGND sg13g2_fill_1
XFILLER_2_335 VPWR VGND sg13g2_fill_1
XFILLER_2_346 VPWR VGND sg13g2_decap_8
XFILLER_3_836 VPWR VGND sg13g2_decap_8
XFILLER_46_545 VPWR VGND sg13g2_decap_8
XFILLER_15_954 VPWR VGND sg13g2_decap_8
XFILLER_27_770 VPWR VGND sg13g2_decap_8
XFILLER_42_795 VPWR VGND sg13g2_decap_8
X_415_ _580_/D _579_/Q _580_/Q _415_/S VPWR VGND sg13g2_mux2_1
X_346_ _511_/D _510_/Q _511_/Q _416_/S VPWR VGND sg13g2_mux2_1
X_277_ _633_/D _611_/Q _625_/Q _278_/S VPWR VGND sg13g2_mux2_1
XFILLER_6_663 VPWR VGND sg13g2_decap_8
XFILLER_5_184 VPWR VGND sg13g2_fill_2
XFILLER_49_350 VPWR VGND sg13g2_decap_8
XFILLER_18_770 VPWR VGND sg13g2_decap_8
XFILLER_33_762 VPWR VGND sg13g2_decap_8
XFILLER_0_806 VPWR VGND sg13g2_decap_8
XFILLER_12_924 VPWR VGND sg13g2_decap_8
XFILLER_24_784 VPWR VGND sg13g2_decap_8
Xclkbuf_5_14__f_clk_regs _555_/CLK clkbuf_4_7_0_clk_regs/X VPWR VGND sg13g2_buf_16
XFILLER_8_917 VPWR VGND sg13g2_decap_8
XFILLER_3_633 VPWR VGND sg13g2_decap_8
XFILLER_46_320 VPWR VGND sg13g2_decap_8
XFILLER_47_821 VPWR VGND sg13g2_decap_8
XFILLER_46_397 VPWR VGND sg13g2_decap_8
XFILLER_15_784 VPWR VGND sg13g2_decap_8
XFILLER_30_798 VPWR VGND sg13g2_decap_8
XFILLER_42_592 VPWR VGND sg13g2_decap_8
X_329_ _494_/D _493_/Q _494_/Q _392_/S VPWR VGND sg13g2_mux2_1
XFILLER_7_961 VPWR VGND sg13g2_decap_8
XFILLER_21_787 VPWR VGND sg13g2_decap_8
XFILLER_0_603 VPWR VGND sg13g2_decap_8
XFILLER_48_607 VPWR VGND sg13g2_decap_8
XFILLER_44_824 VPWR VGND sg13g2_decap_8
XFILLER_12_798 VPWR VGND sg13g2_decap_8
XFILLER_15_1018 VPWR VGND sg13g2_decap_8
XFILLER_7_213 VPWR VGND sg13g2_fill_1
XFILLER_4_964 VPWR VGND sg13g2_decap_8
XFILLER_35_813 VPWR VGND sg13g2_decap_8
XFILLER_35_824 VPWR VGND sg13g2_fill_1
XFILLER_47_695 VPWR VGND sg13g2_decap_8
XFILLER_41_827 VPWR VGND sg13g2_decap_8
XFILLER_0_477 VPWR VGND sg13g2_decap_8
XFILLER_1_923 VPWR VGND sg13g2_decap_8
XFILLER_48_404 VPWR VGND sg13g2_decap_8
XFILLER_44_621 VPWR VGND sg13g2_decap_8
XFILLER_44_698 VPWR VGND sg13g2_decap_8
X_594_ _594_/Q _630_/CLK _594_/D fanout71/X VPWR VGND sg13g2_dfrbpq_1
XFILLER_4_761 VPWR VGND sg13g2_decap_8
XFILLER_6_1027 VPWR VGND sg13g2_fill_2
XFILLER_23_816 VPWR VGND sg13g2_decap_8
Xdelaybuf_10_clk delaybuf_11_clk/A delaybuf_10_clk/A VPWR VGND sg13g2_buf_16
XFILLER_14_805 VPWR VGND sg13g2_decap_8
XFILLER_41_624 VPWR VGND sg13g2_decap_8
XFILLER_45_429 VPWR VGND sg13g2_decap_8
XFILLER_1_720 VPWR VGND sg13g2_decap_8
Xoutput31 uo_out[1] _283_/Y VPWR VGND sg13g2_buf_1
Xoutput20 uio_oe[6] _255_/X VPWR VGND sg13g2_buf_1
XFILLER_5_569 VPWR VGND sg13g2_decap_8
XFILLER_1_797 VPWR VGND sg13g2_decap_8
Xclkbuf_2_0__f_clk_delayed _460_/A clkbuf_0_clk_delayed/X VPWR VGND sg13g2_buf_16
XFILLER_49_735 VPWR VGND sg13g2_decap_8
XFILLER_48_278 VPWR VGND sg13g2_decap_8
X_577_ _577_/Q _577_/CLK _577_/D fanout81/X VPWR VGND sg13g2_dfrbpq_1
X_646_ _646_/Q _460_/Y _647_/D fanout76/X VPWR VGND sg13g2_dfrbpq_1
XFILLER_13_893 VPWR VGND sg13g2_decap_8
XFILLER_9_864 VPWR VGND sg13g2_decap_8
XFILLER_11_819 VPWR VGND sg13g2_decap_8
X_500_ _500_/Q _607_/CLK _500_/D fanout87/X VPWR VGND sg13g2_dfrbpq_1
X_431_ _596_/D _624_/D _596_/Q _432_/S VPWR VGND sg13g2_mux2_1
X_362_ _527_/D _526_/Q _527_/Q _374_/S VPWR VGND sg13g2_mux2_1
XFILLER_10_830 VPWR VGND sg13g2_decap_8
X_293_ _295_/A _470_/Q _473_/Q _474_/Q VPWR VGND sg13g2_nand3b_1
XFILLER_6_845 VPWR VGND sg13g2_decap_8
XFILLER_5_311 VPWR VGND sg13g2_decap_8
XFILLER_1_594 VPWR VGND sg13g2_decap_8
XFILLER_3_79 VPWR VGND sg13g2_fill_2
XFILLER_5_399 VPWR VGND sg13g2_fill_1
XFILLER_49_532 VPWR VGND sg13g2_decap_8
XFILLER_37_749 VPWR VGND sg13g2_decap_8
X_629_ _629_/Q _630_/CLK _629_/D fanout66/X VPWR VGND sg13g2_dfrbpq_1
XFILLER_45_793 VPWR VGND sg13g2_decap_8
Xclkbuf_5_13__f_clk_regs _567_/CLK clkbuf_4_6_0_clk_regs/X VPWR VGND sg13g2_buf_16
XFILLER_3_815 VPWR VGND sg13g2_decap_8
XFILLER_19_749 VPWR VGND sg13g2_decap_8
XFILLER_41_262 VPWR VGND sg13g2_fill_1
XFILLER_42_774 VPWR VGND sg13g2_decap_8
X_414_ _579_/D _605_/D _579_/Q _428_/S VPWR VGND sg13g2_mux2_1
X_345_ _510_/D _509_/Q _510_/Q _415_/S VPWR VGND sg13g2_mux2_1
X_276_ _632_/D _610_/Q _624_/Q _278_/S VPWR VGND sg13g2_mux2_1
XFILLER_6_642 VPWR VGND sg13g2_decap_8
XFILLER_45_590 VPWR VGND sg13g2_decap_8
XFILLER_12_903 VPWR VGND sg13g2_decap_8
XFILLER_24_763 VPWR VGND sg13g2_decap_8
XFILLER_3_612 VPWR VGND sg13g2_decap_8
XFILLER_7_439 VPWR VGND sg13g2_decap_8
XFILLER_3_689 VPWR VGND sg13g2_decap_8
XFILLER_47_800 VPWR VGND sg13g2_decap_8
XFILLER_15_763 VPWR VGND sg13g2_decap_8
XFILLER_46_376 VPWR VGND sg13g2_decap_8
XFILLER_11_980 VPWR VGND sg13g2_decap_8
XFILLER_30_777 VPWR VGND sg13g2_decap_8
XFILLER_42_571 VPWR VGND sg13g2_decap_8
X_328_ _493_/D _492_/Q _493_/Q _350_/S VPWR VGND sg13g2_mux2_1
X_259_ _259_/X _259_/A _259_/B VPWR VGND sg13g2_and2_1
XFILLER_7_940 VPWR VGND sg13g2_decap_8
XFILLER_9_1025 VPWR VGND sg13g2_decap_4
XFILLER_38_833 VPWR VGND sg13g2_decap_8
XFILLER_21_766 VPWR VGND sg13g2_decap_8
XFILLER_0_659 VPWR VGND sg13g2_decap_8
XFILLER_44_803 VPWR VGND sg13g2_decap_8
XFILLER_12_777 VPWR VGND sg13g2_decap_8
XFILLER_7_247 VPWR VGND sg13g2_decap_8
XFILLER_3_486 VPWR VGND sg13g2_decap_8
XFILLER_4_943 VPWR VGND sg13g2_decap_8
XFILLER_47_674 VPWR VGND sg13g2_decap_8
XFILLER_26_847 VPWR VGND sg13g2_decap_4
XFILLER_41_806 VPWR VGND sg13g2_decap_8
XFILLER_1_902 VPWR VGND sg13g2_decap_8
XFILLER_0_456 VPWR VGND sg13g2_decap_8
XFILLER_1_979 VPWR VGND sg13g2_decap_8
XFILLER_49_917 VPWR VGND sg13g2_decap_8
XFILLER_44_600 VPWR VGND sg13g2_decap_8
XFILLER_44_677 VPWR VGND sg13g2_decap_8
X_593_ _622_/D _621_/CLK _593_/D fanout72/X VPWR VGND sg13g2_dfrbpq_1
XFILLER_6_1006 VPWR VGND sg13g2_decap_8
XFILLER_4_740 VPWR VGND sg13g2_decap_8
XFILLER_47_471 VPWR VGND sg13g2_decap_8
XFILLER_45_408 VPWR VGND sg13g2_decap_8
XFILLER_0_253 VPWR VGND sg13g2_fill_2
XFILLER_1_776 VPWR VGND sg13g2_decap_8
Xdelaybuf_3_clk delaybuf_4_clk/A _256_/B VPWR VGND sg13g2_buf_16
Xoutput32 uo_out[2] _285_/Y VPWR VGND sg13g2_buf_1
Xoutput21 uio_oe[7] _258_/Y VPWR VGND sg13g2_buf_1
XFILLER_5_548 VPWR VGND sg13g2_decap_8
XFILLER_49_714 VPWR VGND sg13g2_decap_8
X_645_ _645_/Q _459_/Y _645_/D fanout75/X VPWR VGND sg13g2_dfrbpq_1
XFILLER_13_872 VPWR VGND sg13g2_decap_8
XFILLER_20_809 VPWR VGND sg13g2_decap_8
XFILLER_44_463 VPWR VGND sg13g2_decap_4
X_576_ _576_/Q _649_/CLK _576_/D fanout81/X VPWR VGND sg13g2_dfrbpq_1
XFILLER_9_843 VPWR VGND sg13g2_decap_8
Xclkbuf_5_12__f_clk_regs _570_/CLK clkbuf_4_6_0_clk_regs/X VPWR VGND sg13g2_buf_16
XFILLER_11_1022 VPWR VGND sg13g2_decap_8
XFILLER_2_529 VPWR VGND sg13g2_decap_8
XFILLER_39_791 VPWR VGND sg13g2_decap_8
XFILLER_46_739 VPWR VGND sg13g2_decap_8
X_430_ _595_/D _594_/Q _624_/D _432_/S VPWR VGND sg13g2_mux2_1
X_361_ _526_/D _525_/Q _526_/Q _374_/S VPWR VGND sg13g2_mux2_1
X_292_ _307_/A _473_/Q _474_/Q VPWR VGND sg13g2_and2_1
XFILLER_10_886 VPWR VGND sg13g2_decap_8
XFILLER_6_824 VPWR VGND sg13g2_decap_8
XFILLER_1_573 VPWR VGND sg13g2_decap_8
XFILLER_49_511 VPWR VGND sg13g2_decap_8
XFILLER_44_282 VPWR VGND sg13g2_decap_4
XFILLER_45_772 VPWR VGND sg13g2_decap_8
X_628_ _628_/Q _628_/CLK _628_/D fanout65/X VPWR VGND sg13g2_dfrbpq_1
XFILLER_49_588 VPWR VGND sg13g2_decap_8
X_559_ _559_/Q _562_/CLK _559_/D fanout92/X VPWR VGND sg13g2_dfrbpq_1
X_413_ _578_/D _577_/Q _605_/D _428_/S VPWR VGND sg13g2_mux2_1
XFILLER_15_989 VPWR VGND sg13g2_fill_2
XFILLER_42_753 VPWR VGND sg13g2_decap_8
X_344_ _509_/D _508_/Q _509_/Q _429_/S VPWR VGND sg13g2_mux2_1
X_275_ _631_/D _609_/Q _623_/Q _278_/S VPWR VGND sg13g2_mux2_1
XFILLER_6_621 VPWR VGND sg13g2_decap_8
XFILLER_6_698 VPWR VGND sg13g2_decap_8
XFILLER_2_893 VPWR VGND sg13g2_decap_8
XFILLER_49_385 VPWR VGND sg13g2_decap_8
XFILLER_33_797 VPWR VGND sg13g2_decap_8
XFILLER_12_959 VPWR VGND sg13g2_decap_8
XFILLER_3_668 VPWR VGND sg13g2_decap_8
XFILLER_46_355 VPWR VGND sg13g2_decap_8
XFILLER_30_756 VPWR VGND sg13g2_decap_8
X_327_ _492_/D _491_/Q _492_/Q _350_/S VPWR VGND sg13g2_mux2_1
X_258_ _258_/Y _258_/A _258_/B VPWR VGND sg13g2_nor2_1
XFILLER_2_690 VPWR VGND sg13g2_decap_8
XFILLER_9_1004 VPWR VGND sg13g2_decap_8
XFILLER_7_996 VPWR VGND sg13g2_decap_8
XFILLER_38_812 VPWR VGND sg13g2_decap_8
Xclkbuf_4_9_0_clk_regs clkbuf_4_9_0_clk_regs/X clkbuf_0_clk_regs/X VPWR VGND sg13g2_buf_8
XFILLER_0_638 VPWR VGND sg13g2_decap_8
XFILLER_29_812 VPWR VGND sg13g2_decap_8
XFILLER_29_823 VPWR VGND sg13g2_fill_2
XFILLER_12_756 VPWR VGND sg13g2_decap_8
XFILLER_8_749 VPWR VGND sg13g2_decap_8
XFILLER_3_421 VPWR VGND sg13g2_decap_8
XFILLER_4_999 VPWR VGND sg13g2_decap_8
XFILLER_4_922 VPWR VGND sg13g2_decap_8
XFILLER_47_653 VPWR VGND sg13g2_decap_8
XFILLER_7_793 VPWR VGND sg13g2_decap_8
XFILLER_26_826 VPWR VGND sg13g2_decap_8
XFILLER_0_435 VPWR VGND sg13g2_decap_8
XFILLER_1_958 VPWR VGND sg13g2_decap_8
XFILLER_17_826 VPWR VGND sg13g2_decap_8
X_592_ _592_/Q _621_/CLK _592_/D fanout84/X VPWR VGND sg13g2_dfrbpq_1
XFILLER_48_439 VPWR VGND sg13g2_decap_8
XFILLER_40_851 VPWR VGND sg13g2_fill_1
XFILLER_44_656 VPWR VGND sg13g2_decap_8
XFILLER_3_295 VPWR VGND sg13g2_fill_1
Xclkbuf_5_11__f_clk_regs _533_/CLK clkbuf_4_5_0_clk_regs/X VPWR VGND sg13g2_buf_16
XFILLER_4_796 VPWR VGND sg13g2_decap_8
XFILLER_47_450 VPWR VGND sg13g2_decap_8
XFILLER_31_851 VPWR VGND sg13g2_fill_1
XFILLER_7_590 VPWR VGND sg13g2_decap_8
XFILLER_41_659 VPWR VGND sg13g2_decap_8
XFILLER_5_527 VPWR VGND sg13g2_decap_8
XFILLER_1_755 VPWR VGND sg13g2_decap_8
Xoutput33 uo_out[3] _287_/Y VPWR VGND sg13g2_buf_1
Xoutput22 uio_out[0] _242_/X VPWR VGND sg13g2_buf_1
XFILLER_44_431 VPWR VGND sg13g2_decap_8
X_575_ _575_/Q _577_/CLK _575_/D fanout81/X VPWR VGND sg13g2_dfrbpq_1
X_644_ _644_/Q _458_/Y _644_/D fanout76/X VPWR VGND sg13g2_dfrbpq_1
XFILLER_13_851 VPWR VGND sg13g2_decap_8
XFILLER_9_822 VPWR VGND sg13g2_decap_8
XFILLER_9_899 VPWR VGND sg13g2_decap_8
XFILLER_4_593 VPWR VGND sg13g2_decap_8
XFILLER_11_1001 VPWR VGND sg13g2_decap_8
XFILLER_7_90 VPWR VGND sg13g2_fill_2
XFILLER_2_508 VPWR VGND sg13g2_decap_8
XFILLER_39_770 VPWR VGND sg13g2_decap_8
XFILLER_45_217 VPWR VGND sg13g2_fill_2
XFILLER_46_718 VPWR VGND sg13g2_decap_8
X_360_ _525_/D _524_/Q _525_/Q _374_/S VPWR VGND sg13g2_mux2_1
X_291_ _291_/Y _602_/Q _291_/B VPWR VGND sg13g2_nand2b_1
XFILLER_6_803 VPWR VGND sg13g2_decap_8
XFILLER_10_865 VPWR VGND sg13g2_decap_8
Xclkbuf_4_11_0_clk_regs clkbuf_4_11_0_clk_regs/X clkbuf_0_clk_regs/X VPWR VGND sg13g2_buf_8
XFILLER_5_335 VPWR VGND sg13g2_decap_8
XFILLER_1_552 VPWR VGND sg13g2_decap_8
XFILLER_3_37 VPWR VGND sg13g2_fill_1
XFILLER_49_567 VPWR VGND sg13g2_decap_8
XFILLER_45_751 VPWR VGND sg13g2_decap_8
X_558_ _558_/Q _562_/CLK _558_/D fanout92/X VPWR VGND sg13g2_dfrbpq_1
X_627_ _627_/Q _627_/CLK _627_/D fanout64/X VPWR VGND sg13g2_dfrbpq_1
X_489_ _489_/Q _581_/CLK _489_/D fanout86/X VPWR VGND sg13g2_dfrbpq_1
XFILLER_5_891 VPWR VGND sg13g2_decap_8
XFILLER_12_35 VPWR VGND sg13g2_fill_1
XFILLER_15_968 VPWR VGND sg13g2_fill_1
XFILLER_27_784 VPWR VGND sg13g2_decap_8
XFILLER_42_732 VPWR VGND sg13g2_decap_8
X_412_ _577_/D _576_/Q _577_/Q _412_/S VPWR VGND sg13g2_mux2_1
XFILLER_46_559 VPWR VGND sg13g2_decap_8
X_343_ _508_/D _507_/Q _508_/Q _429_/S VPWR VGND sg13g2_mux2_1
X_274_ _638_/D _616_/Q _630_/Q _278_/S VPWR VGND sg13g2_mux2_1
XFILLER_6_600 VPWR VGND sg13g2_decap_8
XFILLER_2_872 VPWR VGND sg13g2_decap_8
XFILLER_6_677 VPWR VGND sg13g2_decap_8
XFILLER_1_393 VPWR VGND sg13g2_decap_4
XFILLER_49_364 VPWR VGND sg13g2_decap_8
XFILLER_18_784 VPWR VGND sg13g2_decap_8
XFILLER_33_776 VPWR VGND sg13g2_decap_8
XFILLER_12_938 VPWR VGND sg13g2_decap_8
XFILLER_24_798 VPWR VGND sg13g2_decap_8
XFILLER_3_647 VPWR VGND sg13g2_decap_8
XFILLER_46_334 VPWR VGND sg13g2_decap_8
XFILLER_47_835 VPWR VGND sg13g2_decap_8
XFILLER_15_798 VPWR VGND sg13g2_decap_8
X_326_ _491_/D _490_/Q _491_/Q _350_/S VPWR VGND sg13g2_mux2_1
Xfanout90 fanout90/X fanout91/X VPWR VGND sg13g2_buf_1
XFILLER_7_975 VPWR VGND sg13g2_decap_8
XFILLER_6_452 VPWR VGND sg13g2_decap_8
XFILLER_49_161 VPWR VGND sg13g2_fill_1
XFILLER_0_617 VPWR VGND sg13g2_decap_8
XFILLER_47_1022 VPWR VGND sg13g2_decap_8
XFILLER_44_838 VPWR VGND sg13g2_decap_8
XFILLER_4_901 VPWR VGND sg13g2_decap_8
Xclkbuf_5_10__f_clk_regs _571_/CLK clkbuf_4_5_0_clk_regs/X VPWR VGND sg13g2_buf_16
XFILLER_4_978 VPWR VGND sg13g2_decap_8
XFILLER_47_632 VPWR VGND sg13g2_decap_8
X_309_ _474_/D _307_/A _307_/B _308_/Y VPWR VGND sg13g2_a21oi_1
XFILLER_7_772 VPWR VGND sg13g2_decap_8
XFILLER_6_293 VPWR VGND sg13g2_decap_4
XFILLER_26_805 VPWR VGND sg13g2_decap_8
XFILLER_27_0 VPWR VGND sg13g2_fill_2
Xclkbuf_5_29__f_clk_regs _563_/CLK clkbuf_4_14_0_clk_regs/X VPWR VGND sg13g2_buf_16
Xdelaybuf_22_clk delaybuf_22_clk/X delaybuf_22_clk/A VPWR VGND sg13g2_buf_16
XFILLER_5_709 VPWR VGND sg13g2_decap_8
XFILLER_1_937 VPWR VGND sg13g2_decap_8
XFILLER_29_44 VPWR VGND sg13g2_fill_2
Xdelaybuf_13_clk delaybuf_14_clk/A delaybuf_13_clk/A VPWR VGND sg13g2_buf_16
XFILLER_48_418 VPWR VGND sg13g2_decap_8
XFILLER_17_805 VPWR VGND sg13g2_decap_8
XFILLER_43_112 VPWR VGND sg13g2_fill_1
XFILLER_44_635 VPWR VGND sg13g2_decap_8
X_591_ _591_/Q _619_/CLK _591_/D fanout72/X VPWR VGND sg13g2_dfrbpq_1
X_660_ _660_/Q _660_/CLK _660_/D fanout79/X VPWR VGND sg13g2_dfrbpq_1
XFILLER_40_830 VPWR VGND sg13g2_decap_8
XFILLER_6_59 VPWR VGND sg13g2_fill_2
XFILLER_4_775 VPWR VGND sg13g2_decap_8
XFILLER_0_981 VPWR VGND sg13g2_decap_8
XFILLER_43_690 VPWR VGND sg13g2_decap_8
XFILLER_14_819 VPWR VGND sg13g2_decap_8
XFILLER_41_638 VPWR VGND sg13g2_decap_8
Xoutput34 uo_out[4] _289_/Y VPWR VGND sg13g2_buf_1
Xoutput23 uio_out[1] _243_/X VPWR VGND sg13g2_buf_1
XFILLER_0_200 VPWR VGND sg13g2_decap_8
XFILLER_0_211 VPWR VGND sg13g2_fill_1
XFILLER_0_222 VPWR VGND sg13g2_decap_8
XFILLER_1_734 VPWR VGND sg13g2_decap_8
XFILLER_49_749 VPWR VGND sg13g2_decap_8
XFILLER_44_410 VPWR VGND sg13g2_decap_8
X_574_ _574_/Q _577_/CLK _574_/D fanout81/X VPWR VGND sg13g2_dfrbpq_1
X_643_ _643_/Q _457_/Y _643_/D fanout75/X VPWR VGND sg13g2_dfrbpq_1
XFILLER_13_830 VPWR VGND sg13g2_decap_8
XFILLER_9_878 VPWR VGND sg13g2_decap_8
XFILLER_9_801 VPWR VGND sg13g2_decap_8
XFILLER_4_572 VPWR VGND sg13g2_decap_8
XFILLER_48_782 VPWR VGND sg13g2_decap_8
XFILLER_41_413 VPWR VGND sg13g2_decap_4
XFILLER_10_844 VPWR VGND sg13g2_decap_8
X_290_ _311_/S _602_/Q _291_/B VPWR VGND sg13g2_nor2b_1
XFILLER_1_531 VPWR VGND sg13g2_decap_8
XFILLER_6_859 VPWR VGND sg13g2_decap_8
XFILLER_45_730 VPWR VGND sg13g2_decap_8
XFILLER_49_546 VPWR VGND sg13g2_decap_8
XFILLER_44_273 VPWR VGND sg13g2_decap_4
X_557_ _557_/Q _557_/CLK _557_/D fanout96/X VPWR VGND sg13g2_dfrbpq_1
X_626_ _626_/Q _626_/CLK _626_/D fanout69/X VPWR VGND sg13g2_dfrbpq_1
X_488_ _488_/Q _533_/CLK _488_/D fanout90/X VPWR VGND sg13g2_dfrbpq_1
XFILLER_5_870 VPWR VGND sg13g2_decap_8
XFILLER_36_763 VPWR VGND sg13g2_decap_8
XFILLER_3_829 VPWR VGND sg13g2_decap_8
XFILLER_15_947 VPWR VGND sg13g2_decap_8
XFILLER_27_763 VPWR VGND sg13g2_decap_8
XFILLER_42_711 VPWR VGND sg13g2_decap_8
XFILLER_42_788 VPWR VGND sg13g2_decap_8
X_411_ _576_/D _575_/Q _576_/Q _412_/S VPWR VGND sg13g2_mux2_1
X_342_ _507_/D _506_/Q _507_/Q _429_/S VPWR VGND sg13g2_mux2_1
X_273_ _637_/D _615_/Q _629_/Q _278_/S VPWR VGND sg13g2_mux2_1
XFILLER_6_656 VPWR VGND sg13g2_decap_8
XFILLER_5_122 VPWR VGND sg13g2_fill_2
XFILLER_2_851 VPWR VGND sg13g2_decap_8
XFILLER_18_763 VPWR VGND sg13g2_decap_8
X_609_ _609_/Q _623_/CLK _609_/D fanout71/X VPWR VGND sg13g2_dfrbpq_1
XFILLER_49_343 VPWR VGND sg13g2_decap_8
XFILLER_12_917 VPWR VGND sg13g2_decap_8
XFILLER_24_777 VPWR VGND sg13g2_decap_8
XFILLER_3_626 VPWR VGND sg13g2_decap_8
XFILLER_46_313 VPWR VGND sg13g2_decap_8
XFILLER_47_814 VPWR VGND sg13g2_decap_8
XFILLER_15_777 VPWR VGND sg13g2_decap_8
XFILLER_42_585 VPWR VGND sg13g2_decap_8
Xfanout91 fanout91/X fanout97/X VPWR VGND sg13g2_buf_1
Xfanout80 fanout80/X fanout83/X VPWR VGND sg13g2_buf_1
X_325_ _490_/D _489_/Q _490_/Q _350_/S VPWR VGND sg13g2_mux2_1
XFILLER_11_994 VPWR VGND sg13g2_decap_8
X_256_ _256_/Y _460_/A _256_/B VPWR VGND sg13g2_xnor2_1
XFILLER_7_954 VPWR VGND sg13g2_decap_8
XFILLER_6_497 VPWR VGND sg13g2_decap_4
XFILLER_38_847 VPWR VGND sg13g2_decap_4
Xclkbuf_5_28__f_clk_regs _515_/CLK clkbuf_4_14_0_clk_regs/X VPWR VGND sg13g2_buf_16
Xclkbuf_leaf_1_clk _256_/B delaybuf_10_clk/A VPWR VGND sg13g2_buf_8
XFILLER_44_817 VPWR VGND sg13g2_decap_8
Xu_delay_line VPWR VGND u_delay_line/clk clkbuf_0_clk_delayed/A fanout93/X _566_/Q
+ _567_/Q _568_/Q _569_/Q _542_/Q _552_/Q _553_/Q _554_/Q _555_/Q _556_/Q _557_/Q
+ _558_/Q _559_/Q _560_/Q _561_/Q _543_/Q _562_/Q _563_/Q _564_/Q _565_/Q _544_/Q
+ _545_/Q _546_/Q _547_/Q _548_/Q _549_/Q _550_/Q _551_/Q delay_line
Xclkload0 clkload0/X clkload0/A VPWR VGND sg13g2_buf_8
XFILLER_7_228 VPWR VGND sg13g2_fill_2
XFILLER_4_957 VPWR VGND sg13g2_decap_8
XFILLER_47_611 VPWR VGND sg13g2_decap_8
XFILLER_35_806 VPWR VGND sg13g2_decap_8
XFILLER_46_143 VPWR VGND sg13g2_fill_2
XFILLER_47_688 VPWR VGND sg13g2_decap_8
XFILLER_11_791 VPWR VGND sg13g2_decap_8
X_308_ _308_/Y _473_/Q _307_/B _474_/Q VPWR VGND sg13g2_a21oi_1
X_239_ _239_/X _654_/Q _254_/B VPWR VGND sg13g2_and2_1
XFILLER_7_751 VPWR VGND sg13g2_decap_8
XFILLER_3_990 VPWR VGND sg13g2_decap_8
XFILLER_6_283 VPWR VGND sg13g2_decap_4
XFILLER_1_916 VPWR VGND sg13g2_decap_8
XFILLER_44_614 VPWR VGND sg13g2_decap_8
X_590_ _590_/Q _619_/CLK _590_/D fanout72/X VPWR VGND sg13g2_dfrbpq_1
Xdelaybuf_6_clk delaybuf_7_clk/A delaybuf_6_clk/A VPWR VGND sg13g2_buf_16
XFILLER_4_754 VPWR VGND sg13g2_decap_8
XFILLER_0_960 VPWR VGND sg13g2_decap_8
XFILLER_16_861 VPWR VGND sg13g2_decap_8
XFILLER_16_872 VPWR VGND sg13g2_fill_1
XFILLER_23_809 VPWR VGND sg13g2_decap_8
XFILLER_47_485 VPWR VGND sg13g2_decap_4
XFILLER_22_820 VPWR VGND sg13g2_decap_4
XFILLER_41_617 VPWR VGND sg13g2_decap_8
XFILLER_1_713 VPWR VGND sg13g2_decap_8
Xoutput35 uo_out[5] _239_/X VPWR VGND sg13g2_buf_1
Xoutput24 uio_out[2] _244_/X VPWR VGND sg13g2_buf_1
X_642_ _642_/Q _456_/Y _642_/D fanout71/X VPWR VGND sg13g2_dfrbpq_1
XFILLER_49_728 VPWR VGND sg13g2_decap_8
X_573_ _573_/Q _577_/CLK _573_/D fanout81/X VPWR VGND sg13g2_dfrbpq_1
XFILLER_13_886 VPWR VGND sg13g2_decap_8
XFILLER_9_857 VPWR VGND sg13g2_decap_8
XFILLER_4_551 VPWR VGND sg13g2_decap_8
XFILLER_48_761 VPWR VGND sg13g2_decap_8
XFILLER_47_282 VPWR VGND sg13g2_decap_8
XFILLER_10_823 VPWR VGND sg13g2_decap_8
XFILLER_6_838 VPWR VGND sg13g2_decap_8
XFILLER_1_510 VPWR VGND sg13g2_decap_8
XFILLER_1_587 VPWR VGND sg13g2_decap_8
X_625_ _625_/Q _628_/CLK _625_/D fanout68/X VPWR VGND sg13g2_dfrbpq_1
XFILLER_49_525 VPWR VGND sg13g2_decap_8
XFILLER_45_786 VPWR VGND sg13g2_decap_8
X_556_ _556_/Q _557_/CLK _556_/D fanout95/X VPWR VGND sg13g2_dfrbpq_1
X_487_ _487_/Q _533_/CLK _487_/D fanout91/X VPWR VGND sg13g2_dfrbpq_1
XFILLER_3_808 VPWR VGND sg13g2_decap_8
Xhold120 _627_/D _598_/Q VPWR VGND sg13g2_dlygate4sd3_1
XFILLER_2_1012 VPWR VGND sg13g2_decap_8
XFILLER_42_767 VPWR VGND sg13g2_decap_8
X_410_ _575_/D _574_/Q _575_/Q _412_/S VPWR VGND sg13g2_mux2_1
X_341_ _506_/D _505_/Q _506_/Q _415_/S VPWR VGND sg13g2_mux2_1
X_272_ _636_/D _614_/Q _628_/Q _278_/S VPWR VGND sg13g2_mux2_1
XFILLER_6_635 VPWR VGND sg13g2_decap_8
XFILLER_5_156 VPWR VGND sg13g2_fill_1
XFILLER_2_830 VPWR VGND sg13g2_decap_8
Xclkbuf_5_27__f_clk_regs _621_/CLK clkbuf_4_13_0_clk_regs/X VPWR VGND sg13g2_buf_16
XFILLER_49_322 VPWR VGND sg13g2_decap_8
XFILLER_45_583 VPWR VGND sg13g2_decap_8
X_608_ _608_/Q _619_/CLK _608_/D fanout71/X VPWR VGND sg13g2_dfrbpq_1
XFILLER_49_399 VPWR VGND sg13g2_decap_8
X_539_ _539_/Q _626_/CLK _539_/D fanout69/X VPWR VGND sg13g2_dfrbpq_1
XFILLER_24_756 VPWR VGND sg13g2_decap_8
XFILLER_2_104 VPWR VGND sg13g2_fill_1
XFILLER_3_605 VPWR VGND sg13g2_decap_8
XFILLER_46_369 VPWR VGND sg13g2_decap_8
XFILLER_11_973 VPWR VGND sg13g2_decap_8
XFILLER_15_756 VPWR VGND sg13g2_decap_8
XFILLER_42_564 VPWR VGND sg13g2_decap_8
Xfanout70 fanout70/X fanout74/X VPWR VGND sg13g2_buf_1
Xfanout92 fanout92/X fanout93/X VPWR VGND sg13g2_buf_1
Xfanout81 fanout81/X fanout83/X VPWR VGND sg13g2_buf_1
X_324_ _489_/D _488_/Q _489_/Q _415_/S VPWR VGND sg13g2_mux2_1
X_255_ _255_/X _645_/Q _255_/B VPWR VGND sg13g2_and2_1
XFILLER_7_933 VPWR VGND sg13g2_decap_8
XFILLER_9_1018 VPWR VGND sg13g2_decap_8
XFILLER_38_826 VPWR VGND sg13g2_decap_8
XFILLER_45_380 VPWR VGND sg13g2_decap_8
XFILLER_21_759 VPWR VGND sg13g2_decap_8
Xclkload1 clkload1/Y _449_/B VPWR VGND sg13g2_inv_4
XFILLER_20_781 VPWR VGND sg13g2_decap_8
XFILLER_3_402 VPWR VGND sg13g2_decap_8
XFILLER_3_435 VPWR VGND sg13g2_decap_8
XFILLER_3_479 VPWR VGND sg13g2_decap_8
XFILLER_4_936 VPWR VGND sg13g2_decap_8
XFILLER_43_851 VPWR VGND sg13g2_fill_1
XFILLER_46_199 VPWR VGND sg13g2_fill_2
XFILLER_47_667 VPWR VGND sg13g2_decap_8
XFILLER_11_770 VPWR VGND sg13g2_decap_8
X_307_ _310_/B _307_/A _307_/B VPWR VGND sg13g2_nand2_1
X_238_ _258_/A _254_/B VPWR VGND sg13g2_inv_1
XFILLER_7_730 VPWR VGND sg13g2_decap_8
XFILLER_14_1012 VPWR VGND sg13g2_decap_8
XFILLER_0_449 VPWR VGND sg13g2_decap_8
XFILLER_25_840 VPWR VGND sg13g2_decap_8
XFILLER_25_851 VPWR VGND sg13g2_fill_1
Xclkbuf_4_8_0_clk_regs clkbuf_4_8_0_clk_regs/X clkbuf_0_clk_regs/X VPWR VGND sg13g2_buf_8
XFILLER_4_733 VPWR VGND sg13g2_decap_8
XFILLER_47_464 VPWR VGND sg13g2_decap_8
XFILLER_16_840 VPWR VGND sg13g2_decap_8
XFILLER_1_769 VPWR VGND sg13g2_decap_8
Xoutput36 uo_out[6] _240_/X VPWR VGND sg13g2_buf_1
Xoutput25 uio_out[3] _245_/X VPWR VGND sg13g2_buf_1
Xoutput14 uio_oe[0] _249_/X VPWR VGND sg13g2_buf_1
XFILLER_49_707 VPWR VGND sg13g2_decap_8
X_572_ _572_/Q _577_/CLK _572_/D fanout82/X VPWR VGND sg13g2_dfrbpq_1
X_641_ _641_/Q _455_/Y _641_/D fanout85/X VPWR VGND sg13g2_dfrbpq_1
XFILLER_5_1010 VPWR VGND sg13g2_decap_8
XFILLER_13_865 VPWR VGND sg13g2_decap_8
XFILLER_9_836 VPWR VGND sg13g2_decap_8
XFILLER_4_530 VPWR VGND sg13g2_decap_8
XFILLER_48_740 VPWR VGND sg13g2_decap_8
XFILLER_11_1015 VPWR VGND sg13g2_decap_8
XFILLER_39_784 VPWR VGND sg13g2_decap_8
XFILLER_10_802 VPWR VGND sg13g2_decap_8
XFILLER_10_879 VPWR VGND sg13g2_decap_8
XFILLER_6_817 VPWR VGND sg13g2_decap_8
XFILLER_1_566 VPWR VGND sg13g2_decap_8
Xclkbuf_5_26__f_clk_regs _579_/CLK clkbuf_4_13_0_clk_regs/X VPWR VGND sg13g2_buf_16
XFILLER_49_504 VPWR VGND sg13g2_decap_8
XFILLER_45_765 VPWR VGND sg13g2_decap_8
X_555_ _555_/Q _555_/CLK _555_/D fanout95/X VPWR VGND sg13g2_dfrbpq_1
X_624_ _624_/Q _628_/CLK _624_/D fanout68/X VPWR VGND sg13g2_dfrbpq_1
XFILLER_44_286 VPWR VGND sg13g2_fill_2
X_486_ _486_/Q _533_/CLK _486_/D fanout91/X VPWR VGND sg13g2_dfrbpq_1
Xhold110 _660_/D _464_/Q VPWR VGND sg13g2_dlygate4sd3_1
Xhold121 _619_/D _590_/Q VPWR VGND sg13g2_dlygate4sd3_1
XFILLER_27_798 VPWR VGND sg13g2_decap_8
XFILLER_41_234 VPWR VGND sg13g2_fill_1
XFILLER_42_746 VPWR VGND sg13g2_decap_8
X_340_ _505_/D _504_/Q _505_/Q _415_/S VPWR VGND sg13g2_mux2_1
X_271_ _635_/D _613_/Q _627_/Q _278_/S VPWR VGND sg13g2_mux2_1
XFILLER_6_614 VPWR VGND sg13g2_decap_8
XFILLER_5_124 VPWR VGND sg13g2_fill_1
XFILLER_2_886 VPWR VGND sg13g2_decap_8
XFILLER_49_378 VPWR VGND sg13g2_decap_8
XFILLER_49_301 VPWR VGND sg13g2_decap_8
XFILLER_18_798 VPWR VGND sg13g2_decap_8
XFILLER_45_562 VPWR VGND sg13g2_decap_8
X_538_ _538_/Q _612_/CLK _538_/D fanout69/X VPWR VGND sg13g2_dfrbpq_1
X_607_ _607_/Q _607_/CLK _607_/D fanout85/X VPWR VGND sg13g2_dfrbpq_1
X_469_ _469_/Q _652_/CLK _469_/D fanout80/X VPWR VGND sg13g2_dfrbpq_1
Xclkbuf_4_10_0_clk_regs clkbuf_4_10_0_clk_regs/X clkbuf_0_clk_regs/X VPWR VGND sg13g2_buf_8
XFILLER_2_149 VPWR VGND sg13g2_fill_1
XFILLER_46_348 VPWR VGND sg13g2_decap_8
XFILLER_47_849 VPWR VGND sg13g2_decap_4
XFILLER_11_952 VPWR VGND sg13g2_decap_8
XFILLER_30_749 VPWR VGND sg13g2_decap_8
Xfanout60 _392_/S _291_/Y VPWR VGND sg13g2_buf_1
Xfanout71 fanout71/X fanout73/X VPWR VGND sg13g2_buf_1
Xfanout93 fanout93/X fanout96/X VPWR VGND sg13g2_buf_1
Xfanout82 fanout82/X fanout83/X VPWR VGND sg13g2_buf_1
X_323_ _488_/D _487_/Q _488_/Q _323_/S VPWR VGND sg13g2_mux2_1
X_254_ _254_/X _643_/Q _254_/B VPWR VGND sg13g2_and2_1
XFILLER_7_912 VPWR VGND sg13g2_decap_8
XFILLER_2_683 VPWR VGND sg13g2_decap_8
XFILLER_7_989 VPWR VGND sg13g2_decap_8
XFILLER_38_805 VPWR VGND sg13g2_decap_8
Xdelaybuf_25_clk delaybuf_26_clk/A delaybuf_25_clk/A VPWR VGND sg13g2_buf_16
XFILLER_29_805 VPWR VGND sg13g2_decap_8
XFILLER_12_749 VPWR VGND sg13g2_decap_8
Xclkload2 clkload2/Y _440_/B VPWR VGND sg13g2_inv_4
Xdelaybuf_16_clk delaybuf_16_clk/X delaybuf_16_clk/A VPWR VGND sg13g2_buf_16
XFILLER_4_915 VPWR VGND sg13g2_decap_8
XFILLER_47_646 VPWR VGND sg13g2_decap_8
X_306_ _473_/D _473_/Q _307_/B VPWR VGND sg13g2_xor2_1
X_237_ _255_/B _281_/A _279_/B VPWR VGND sg13g2_and2_1
XFILLER_7_786 VPWR VGND sg13g2_decap_8
XFILLER_2_480 VPWR VGND sg13g2_decap_8
XFILLER_26_819 VPWR VGND sg13g2_decap_8
XFILLER_0_428 VPWR VGND sg13g2_decap_8
XFILLER_17_819 VPWR VGND sg13g2_decap_8
XFILLER_40_844 VPWR VGND sg13g2_decap_8
XFILLER_44_649 VPWR VGND sg13g2_decap_8
XFILLER_4_712 VPWR VGND sg13g2_decap_8
XFILLER_3_255 VPWR VGND sg13g2_decap_4
XFILLER_4_789 VPWR VGND sg13g2_decap_8
XFILLER_0_995 VPWR VGND sg13g2_decap_8
XFILLER_47_443 VPWR VGND sg13g2_decap_8
XFILLER_31_844 VPWR VGND sg13g2_decap_8
XFILLER_7_583 VPWR VGND sg13g2_decap_8
XFILLER_25_0 VPWR VGND sg13g2_fill_2
Xclkbuf_5_25__f_clk_regs _514_/CLK clkbuf_4_12_0_clk_regs/X VPWR VGND sg13g2_buf_16
XFILLER_1_748 VPWR VGND sg13g2_decap_8
Xoutput37 uo_out[7] _241_/X VPWR VGND sg13g2_buf_1
Xoutput26 uio_out[4] _248_/B VPWR VGND sg13g2_buf_1
Xoutput15 uio_oe[1] _250_/X VPWR VGND sg13g2_buf_1
XFILLER_44_424 VPWR VGND sg13g2_decap_8
X_571_ _571_/Q _571_/CLK _571_/D fanout82/X VPWR VGND sg13g2_dfrbpq_1
X_640_ _640_/Q _454_/Y _640_/D fanout85/X VPWR VGND sg13g2_dfrbpq_1
XFILLER_13_844 VPWR VGND sg13g2_decap_8
XFILLER_9_815 VPWR VGND sg13g2_decap_8
XFILLER_4_586 VPWR VGND sg13g2_decap_8
XFILLER_0_792 VPWR VGND sg13g2_decap_8
Xclkbuf_0_clk_delayed clkbuf_0_clk_delayed/X clkbuf_0_clk_delayed/A VPWR VGND sg13g2_buf_16
XFILLER_48_796 VPWR VGND sg13g2_decap_8
XFILLER_39_763 VPWR VGND sg13g2_decap_8
Xclkbuf_5_9__f_clk_regs _581_/CLK clkbuf_4_4_0_clk_regs/X VPWR VGND sg13g2_buf_16
XFILLER_10_858 VPWR VGND sg13g2_decap_8
XFILLER_1_545 VPWR VGND sg13g2_decap_8
XFILLER_45_744 VPWR VGND sg13g2_decap_8
X_554_ _554_/Q _555_/CLK _554_/D fanout95/X VPWR VGND sg13g2_dfrbpq_1
X_623_ _623_/Q _623_/CLK _623_/D fanout71/X VPWR VGND sg13g2_dfrbpq_1
X_485_ _485_/Q _555_/CLK _485_/D fanout90/X VPWR VGND sg13g2_dfrbpq_1
XFILLER_5_884 VPWR VGND sg13g2_decap_8
XFILLER_4_361 VPWR VGND sg13g2_decap_8
XFILLER_48_593 VPWR VGND sg13g2_decap_8
XFILLER_36_777 VPWR VGND sg13g2_decap_4
Xhold122 _628_/D _599_/Q VPWR VGND sg13g2_dlygate4sd3_1
Xhold111 _654_/D _466_/Q VPWR VGND sg13g2_dlygate4sd3_1
Xhold100 _259_/B _644_/Q VPWR VGND sg13g2_dlygate4sd3_1
XFILLER_27_777 VPWR VGND sg13g2_decap_8
XFILLER_42_725 VPWR VGND sg13g2_decap_8
X_270_ _642_/D _608_/Q _622_/Q _270_/S VPWR VGND sg13g2_mux2_1
XFILLER_2_865 VPWR VGND sg13g2_decap_8
XFILLER_1_397 VPWR VGND sg13g2_fill_2
XFILLER_49_357 VPWR VGND sg13g2_decap_8
XFILLER_14_972 VPWR VGND sg13g2_decap_8
XFILLER_14_983 VPWR VGND sg13g2_fill_2
XFILLER_18_777 VPWR VGND sg13g2_decap_8
XFILLER_33_769 VPWR VGND sg13g2_decap_8
XFILLER_45_541 VPWR VGND sg13g2_decap_8
X_537_ _537_/Q _627_/CLK _537_/D fanout73/X VPWR VGND sg13g2_dfrbpq_1
X_606_ _606_/Q _621_/CLK _606_/D fanout84/X VPWR VGND sg13g2_dfrbpq_1
X_468_ _656_/D _444_/Y _468_/D fanout77/X VPWR VGND sg13g2_dfrbpq_1
X_399_ _564_/D _563_/Q _564_/Q _405_/S VPWR VGND sg13g2_mux2_1
Xclkbuf_leaf_4_clk _456_/B clkload0/A VPWR VGND sg13g2_buf_8
XFILLER_5_681 VPWR VGND sg13g2_decap_8
XFILLER_48_390 VPWR VGND sg13g2_decap_8
XFILLER_32_791 VPWR VGND sg13g2_decap_8
XFILLER_46_327 VPWR VGND sg13g2_decap_8
XFILLER_47_828 VPWR VGND sg13g2_decap_8
X_322_ _487_/D _486_/Q _487_/Q _322_/S VPWR VGND sg13g2_mux2_1
XFILLER_11_931 VPWR VGND sg13g2_decap_8
XFILLER_42_599 VPWR VGND sg13g2_decap_8
Xfanout50 _415_/S _416_/S VPWR VGND sg13g2_buf_1
Xfanout61 _248_/B _254_/B VPWR VGND sg13g2_buf_1
Xfanout72 fanout72/X fanout73/X VPWR VGND sg13g2_buf_1
Xfanout94 fanout94/X fanout95/X VPWR VGND sg13g2_buf_1
Xfanout83 fanout83/X fanout97/X VPWR VGND sg13g2_buf_1
X_253_ _253_/X _634_/Q _254_/B VPWR VGND sg13g2_and2_1
XFILLER_7_968 VPWR VGND sg13g2_decap_8
XFILLER_6_423 VPWR VGND sg13g2_fill_2
XFILLER_2_662 VPWR VGND sg13g2_decap_8
XFILLER_14_791 VPWR VGND sg13g2_decap_8
Xclkload20 clkload20/Y _459_/A VPWR VGND sg13g2_inv_4
XFILLER_47_1015 VPWR VGND sg13g2_decap_8
Xclkload3 clkload3/Y _541_/CLK VPWR VGND sg13g2_inv_1
XFILLER_47_625 VPWR VGND sg13g2_decap_8
XFILLER_43_842 VPWR VGND sg13g2_decap_8
Xdelaybuf_9_clk _460_/B delaybuf_9_clk/A VPWR VGND sg13g2_buf_16
X_305_ _472_/D _220_/Y _301_/Y _307_/B VPWR VGND sg13g2_a21oi_1
X_236_ _461_/D _236_/A0 _461_/Q _236_/S VPWR VGND sg13g2_mux2_1
XFILLER_7_765 VPWR VGND sg13g2_decap_8
XFILLER_6_297 VPWR VGND sg13g2_fill_2
Xclkbuf_5_24__f_clk_regs _607_/CLK clkbuf_4_12_0_clk_regs/X VPWR VGND sg13g2_buf_16
XFILLER_44_628 VPWR VGND sg13g2_decap_8
XFILLER_40_823 VPWR VGND sg13g2_decap_8
XFILLER_4_768 VPWR VGND sg13g2_decap_8
XFILLER_0_974 VPWR VGND sg13g2_decap_8
XFILLER_48_901 VPWR VGND sg13g2_fill_1
XFILLER_47_422 VPWR VGND sg13g2_decap_8
XFILLER_43_683 VPWR VGND sg13g2_decap_8
X_219_ _304_/A _470_/Q VPWR VGND sg13g2_inv_1
XFILLER_7_562 VPWR VGND sg13g2_decap_8
Xclkbuf_5_8__f_clk_regs _534_/CLK clkbuf_4_4_0_clk_regs/X VPWR VGND sg13g2_buf_16
XFILLER_1_727 VPWR VGND sg13g2_decap_8
Xoutput27 uio_out[5] _246_/X VPWR VGND sg13g2_buf_1
Xoutput16 uio_oe[2] _251_/X VPWR VGND sg13g2_buf_1
XFILLER_44_403 VPWR VGND sg13g2_decap_8
X_570_ _570_/Q _570_/CLK _570_/D fanout94/X VPWR VGND sg13g2_dfrbpq_1
XFILLER_13_823 VPWR VGND sg13g2_decap_8
XFILLER_4_565 VPWR VGND sg13g2_decap_8
XFILLER_0_771 VPWR VGND sg13g2_decap_8
XFILLER_48_775 VPWR VGND sg13g2_decap_8
XFILLER_47_252 VPWR VGND sg13g2_decap_4
Xclkbuf_0_clk clkbuf_0_clk/X clk VPWR VGND sg13g2_buf_16
XFILLER_47_296 VPWR VGND sg13g2_decap_8
XFILLER_8_882 VPWR VGND sg13g2_decap_8
XFILLER_10_837 VPWR VGND sg13g2_decap_8
XFILLER_41_417 VPWR VGND sg13g2_fill_1
XFILLER_1_524 VPWR VGND sg13g2_decap_8
XFILLER_5_318 VPWR VGND sg13g2_decap_8
X_622_ _622_/Q _623_/CLK _622_/D fanout71/X VPWR VGND sg13g2_dfrbpq_1
XFILLER_49_539 VPWR VGND sg13g2_decap_8
XFILLER_44_277 VPWR VGND sg13g2_fill_1
XFILLER_45_723 VPWR VGND sg13g2_decap_8
X_553_ _553_/Q _570_/CLK _553_/D fanout95/X VPWR VGND sg13g2_dfrbpq_1
X_484_ _484_/Q _555_/CLK _484_/D fanout96/X VPWR VGND sg13g2_dfrbpq_1
XFILLER_5_863 VPWR VGND sg13g2_decap_8
XFILLER_36_756 VPWR VGND sg13g2_decap_8
XFILLER_48_572 VPWR VGND sg13g2_decap_8
XFILLER_17_992 VPWR VGND sg13g2_decap_8
Xhold123 _629_/D _600_/Q VPWR VGND sg13g2_dlygate4sd3_1
Xhold112 _620_/D _591_/Q VPWR VGND sg13g2_dlygate4sd3_1
Xhold101 _648_/D _259_/X VPWR VGND sg13g2_dlygate4sd3_1
XFILLER_27_756 VPWR VGND sg13g2_decap_8
XFILLER_2_1026 VPWR VGND sg13g2_fill_2
XFILLER_42_704 VPWR VGND sg13g2_decap_8
XFILLER_6_649 VPWR VGND sg13g2_decap_8
XFILLER_2_844 VPWR VGND sg13g2_decap_8
Xclkbuf_2_3__f_clk_delayed _459_/A clkbuf_0_clk_delayed/X VPWR VGND sg13g2_buf_16
XFILLER_18_756 VPWR VGND sg13g2_decap_8
X_605_ _605_/Q _619_/CLK _605_/D fanout72/X VPWR VGND sg13g2_dfrbpq_1
XFILLER_49_336 VPWR VGND sg13g2_decap_8
XFILLER_41_792 VPWR VGND sg13g2_decap_8
XFILLER_45_597 VPWR VGND sg13g2_decap_8
X_536_ _536_/Q _579_/CLK _536_/D fanout73/X VPWR VGND sg13g2_dfrbpq_1
X_467_ _655_/D _443_/Y _467_/D fanout77/X VPWR VGND sg13g2_dfrbpq_1
X_398_ _563_/D _562_/Q _563_/Q _398_/S VPWR VGND sg13g2_mux2_1
XFILLER_5_660 VPWR VGND sg13g2_decap_8
XFILLER_4_85 VPWR VGND sg13g2_fill_1
XFILLER_4_181 VPWR VGND sg13g2_decap_4
XFILLER_32_770 VPWR VGND sg13g2_decap_8
XFILLER_3_619 VPWR VGND sg13g2_decap_8
XFILLER_46_306 VPWR VGND sg13g2_decap_8
XFILLER_47_807 VPWR VGND sg13g2_decap_8
XFILLER_11_910 VPWR VGND sg13g2_decap_8
XFILLER_23_781 VPWR VGND sg13g2_decap_8
XFILLER_42_578 VPWR VGND sg13g2_decap_8
Xfanout40 _436_/S _432_/S VPWR VGND sg13g2_buf_1
Xfanout51 _349_/S _350_/S VPWR VGND sg13g2_buf_1
Xfanout62 _252_/B _254_/B VPWR VGND sg13g2_buf_1
Xfanout73 fanout73/X fanout74/X VPWR VGND sg13g2_buf_1
X_321_ _486_/D _485_/Q _486_/Q _323_/S VPWR VGND sg13g2_mux2_1
X_252_ _252_/X _633_/Q _252_/B VPWR VGND sg13g2_and2_1
XFILLER_11_987 VPWR VGND sg13g2_decap_8
Xfanout95 fanout95/X fanout96/X VPWR VGND sg13g2_buf_1
Xfanout84 fanout84/X fanout86/X VPWR VGND sg13g2_buf_1
XFILLER_7_947 VPWR VGND sg13g2_decap_8
XFILLER_2_641 VPWR VGND sg13g2_decap_8
XFILLER_45_394 VPWR VGND sg13g2_decap_8
XFILLER_46_851 VPWR VGND sg13g2_fill_1
XFILLER_14_770 VPWR VGND sg13g2_decap_8
Xclkbuf_5_23__f_clk_regs _619_/CLK clkbuf_4_11_0_clk_regs/X VPWR VGND sg13g2_buf_16
Xclkload10 clkload10/Y _616_/CLK VPWR VGND sg13g2_inv_1
X_519_ _519_/Q _571_/CLK _519_/D fanout82/X VPWR VGND sg13g2_dfrbpq_1
XFILLER_5_490 VPWR VGND sg13g2_fill_2
XFILLER_20_795 VPWR VGND sg13g2_decap_8
Xclkload4 clkload4/Y _649_/CLK VPWR VGND sg13g2_inv_1
XFILLER_47_604 VPWR VGND sg13g2_decap_8
XFILLER_43_821 VPWR VGND sg13g2_decap_8
XFILLER_11_784 VPWR VGND sg13g2_decap_8
XFILLER_24_71 VPWR VGND sg13g2_fill_2
XFILLER_42_342 VPWR VGND sg13g2_decap_4
X_304_ _307_/B _304_/A _366_/S _304_/C VPWR VGND sg13g2_nor3_1
X_235_ _462_/D _235_/A0 _658_/D _236_/S VPWR VGND sg13g2_mux2_1
XFILLER_3_983 VPWR VGND sg13g2_decap_8
XFILLER_7_744 VPWR VGND sg13g2_decap_8
XFILLER_6_287 VPWR VGND sg13g2_fill_2
XFILLER_1_64 VPWR VGND sg13g2_fill_1
Xclkbuf_5_7__f_clk_regs _659_/CLK clkbuf_4_3_0_clk_regs/X VPWR VGND sg13g2_buf_16
XFILLER_14_1026 VPWR VGND sg13g2_fill_2
XFILLER_1_909 VPWR VGND sg13g2_decap_8
XFILLER_44_607 VPWR VGND sg13g2_decap_8
XFILLER_40_802 VPWR VGND sg13g2_decap_8
XFILLER_4_747 VPWR VGND sg13g2_decap_8
XFILLER_0_953 VPWR VGND sg13g2_decap_8
Xclkbuf_regs_0_clk clkbuf_regs_0_clk/X delaybuf_28_clk/X VPWR VGND sg13g2_buf_16
XFILLER_47_401 VPWR VGND sg13g2_decap_8
XFILLER_16_854 VPWR VGND sg13g2_decap_8
XFILLER_47_489 VPWR VGND sg13g2_fill_2
XFILLER_47_478 VPWR VGND sg13g2_decap_8
X_218_ _218_/Y _469_/Q VPWR VGND sg13g2_inv_1
XFILLER_7_541 VPWR VGND sg13g2_decap_8
XFILLER_3_780 VPWR VGND sg13g2_decap_8
XFILLER_22_813 VPWR VGND sg13g2_decap_8
XFILLER_22_824 VPWR VGND sg13g2_fill_1
XFILLER_1_706 VPWR VGND sg13g2_decap_8
Xoutput28 uio_out[6] _247_/X VPWR VGND sg13g2_buf_1
Xoutput17 uio_oe[3] _252_/X VPWR VGND sg13g2_buf_1
XFILLER_5_1024 VPWR VGND sg13g2_decap_4
XFILLER_13_802 VPWR VGND sg13g2_decap_8
XFILLER_13_879 VPWR VGND sg13g2_decap_8
XFILLER_0_750 VPWR VGND sg13g2_decap_8
XFILLER_4_544 VPWR VGND sg13g2_decap_8
XFILLER_48_754 VPWR VGND sg13g2_decap_8
XFILLER_8_861 VPWR VGND sg13g2_decap_8
XFILLER_39_798 VPWR VGND sg13g2_decap_8
Xclkbuf_4_7_0_clk_regs clkbuf_4_7_0_clk_regs/X clkbuf_0_clk_regs/X VPWR VGND sg13g2_buf_8
XFILLER_10_816 VPWR VGND sg13g2_decap_8
XFILLER_1_503 VPWR VGND sg13g2_decap_8
XFILLER_45_702 VPWR VGND sg13g2_decap_8
X_621_ _621_/Q _621_/CLK _621_/D fanout84/X VPWR VGND sg13g2_dfrbpq_1
XFILLER_49_518 VPWR VGND sg13g2_decap_8
XFILLER_45_779 VPWR VGND sg13g2_decap_8
X_552_ _552_/Q _567_/CLK _552_/D fanout94/X VPWR VGND sg13g2_dfrbpq_1
X_483_ _483_/Q _570_/CLK _483_/D fanout96/X VPWR VGND sg13g2_dfrbpq_1
XFILLER_5_842 VPWR VGND sg13g2_decap_8
XFILLER_17_971 VPWR VGND sg13g2_decap_8
XFILLER_48_551 VPWR VGND sg13g2_decap_8
Xhold124 _623_/D _594_/Q VPWR VGND sg13g2_dlygate4sd3_1
Xhold113 _614_/D _587_/Q VPWR VGND sg13g2_dlygate4sd3_1
Xhold102 hold102/X _646_/Q VPWR VGND sg13g2_dlygate4sd3_1
XFILLER_2_1005 VPWR VGND sg13g2_decap_8
XFILLER_6_628 VPWR VGND sg13g2_decap_8
XFILLER_2_823 VPWR VGND sg13g2_decap_8
XFILLER_49_315 VPWR VGND sg13g2_decap_8
XFILLER_45_576 VPWR VGND sg13g2_decap_8
X_535_ _535_/Q _571_/CLK _535_/D fanout81/X VPWR VGND sg13g2_dfrbpq_1
X_604_ _604_/Q _657_/CLK _604_/D fanout76/X VPWR VGND sg13g2_dfrbpq_1
XFILLER_41_771 VPWR VGND sg13g2_decap_8
Xclkbuf_5_22__f_clk_regs _623_/CLK clkbuf_4_11_0_clk_regs/X VPWR VGND sg13g2_buf_16
X_466_ _466_/Q _442_/Y _466_/D fanout77/X VPWR VGND sg13g2_dfrbpq_1
X_397_ _562_/D _561_/Q _562_/Q _397_/S VPWR VGND sg13g2_mux2_1
XFILLER_49_882 VPWR VGND sg13g2_decap_8
XFILLER_24_749 VPWR VGND sg13g2_decap_8
Xdelaybuf_28_clk delaybuf_28_clk/X delaybuf_28_clk/A VPWR VGND sg13g2_buf_16
XFILLER_11_966 VPWR VGND sg13g2_decap_8
XFILLER_15_749 VPWR VGND sg13g2_decap_8
Xfanout41 _432_/S fanout46/X VPWR VGND sg13g2_buf_1
Xfanout52 _350_/S _416_/S VPWR VGND sg13g2_buf_1
Xfanout63 _254_/B _255_/B VPWR VGND sg13g2_buf_1
Xfanout74 fanout74/X fanout97/X VPWR VGND sg13g2_buf_1
Xfanout96 fanout96/X fanout97/X VPWR VGND sg13g2_buf_1
Xfanout85 fanout85/X fanout86/X VPWR VGND sg13g2_buf_1
X_320_ _485_/D _484_/Q _485_/Q _323_/S VPWR VGND sg13g2_mux2_1
X_251_ _251_/X _632_/Q _252_/B VPWR VGND sg13g2_and2_1
XFILLER_7_926 VPWR VGND sg13g2_decap_8
XFILLER_2_620 VPWR VGND sg13g2_decap_8
Xdelaybuf_19_clk delaybuf_20_clk/A delaybuf_19_clk/A VPWR VGND sg13g2_buf_16
XFILLER_2_697 VPWR VGND sg13g2_decap_8
XFILLER_38_819 VPWR VGND sg13g2_decap_8
Xclkbuf_5_6__f_clk_regs _660_/CLK clkbuf_4_3_0_clk_regs/X VPWR VGND sg13g2_buf_16
XFILLER_45_373 VPWR VGND sg13g2_decap_8
X_518_ _518_/Q _649_/CLK _518_/D fanout80/X VPWR VGND sg13g2_dfrbpq_1
XFILLER_46_830 VPWR VGND sg13g2_decap_8
Xclkload11 clkload11/Y _612_/CLK VPWR VGND sg13g2_inv_1
X_449_ _449_/Y _456_/A _449_/B VPWR VGND sg13g2_xnor2_1
XFILLER_6_992 VPWR VGND sg13g2_decap_8
XFILLER_29_819 VPWR VGND sg13g2_decap_4
Xclkload5 clkload5/Y _577_/CLK VPWR VGND sg13g2_inv_1
XFILLER_20_774 VPWR VGND sg13g2_decap_8
XFILLER_3_428 VPWR VGND sg13g2_decap_8
XFILLER_4_929 VPWR VGND sg13g2_decap_8
XFILLER_43_800 VPWR VGND sg13g2_decap_8
XFILLER_11_763 VPWR VGND sg13g2_decap_8
X_303_ _304_/C _469_/Q _471_/Q _472_/Q VPWR VGND sg13g2_nand3_1
X_234_ _463_/D _234_/A0 _463_/Q _236_/S VPWR VGND sg13g2_mux2_1
XFILLER_7_723 VPWR VGND sg13g2_decap_8
XFILLER_6_200 VPWR VGND sg13g2_fill_1
XFILLER_3_962 VPWR VGND sg13g2_decap_8
XFILLER_2_494 VPWR VGND sg13g2_decap_8
XFILLER_46_671 VPWR VGND sg13g2_decap_8
XFILLER_46_682 VPWR VGND sg13g2_fill_2
XFILLER_25_833 VPWR VGND sg13g2_decap_8
Xclkbuf_0__017__regs clkbuf_0__017__regs/X clkbuf_regs_1_clk/X VPWR VGND sg13g2_buf_16
XFILLER_0_932 VPWR VGND sg13g2_decap_8
XFILLER_4_726 VPWR VGND sg13g2_decap_8
XFILLER_48_958 VPWR VGND sg13g2_fill_1
XFILLER_47_457 VPWR VGND sg13g2_decap_8
XFILLER_16_833 VPWR VGND sg13g2_decap_8
XFILLER_7_597 VPWR VGND sg13g2_decap_8
Xoutput29 uio_out[7] _248_/X VPWR VGND sg13g2_buf_1
Xoutput18 uio_oe[4] _253_/X VPWR VGND sg13g2_buf_1
XFILLER_5_1003 VPWR VGND sg13g2_decap_8
XFILLER_13_858 VPWR VGND sg13g2_decap_8
XFILLER_9_829 VPWR VGND sg13g2_decap_8
XFILLER_4_523 VPWR VGND sg13g2_decap_8
XFILLER_48_733 VPWR VGND sg13g2_decap_8
XFILLER_43_460 VPWR VGND sg13g2_decap_4
XFILLER_8_840 VPWR VGND sg13g2_decap_8
XFILLER_11_1008 VPWR VGND sg13g2_decap_8
XFILLER_7_31 VPWR VGND sg13g2_fill_2
XFILLER_39_777 VPWR VGND sg13g2_decap_8
XFILLER_1_559 VPWR VGND sg13g2_decap_8
XFILLER_45_758 VPWR VGND sg13g2_decap_8
X_551_ _551_/Q _561_/CLK _551_/D fanout93/X VPWR VGND sg13g2_dfrbpq_1
X_620_ _620_/Q _621_/CLK _620_/D fanout84/X VPWR VGND sg13g2_dfrbpq_1
Xclkbuf_5_21__f_clk_regs _630_/CLK clkbuf_4_10_0_clk_regs/X VPWR VGND sg13g2_buf_16
X_482_ _482_/Q _570_/CLK _482_/D fanout96/X VPWR VGND sg13g2_dfrbpq_1
XFILLER_5_898 VPWR VGND sg13g2_decap_8
XFILLER_5_821 VPWR VGND sg13g2_decap_8
XFILLER_4_331 VPWR VGND sg13g2_fill_2
XFILLER_48_530 VPWR VGND sg13g2_decap_8
Xhold125 _606_/D _579_/Q VPWR VGND sg13g2_dlygate4sd3_1
Xhold114 _613_/D _586_/Q VPWR VGND sg13g2_dlygate4sd3_1
Xhold103 _657_/D _461_/Q VPWR VGND sg13g2_dlygate4sd3_1
XFILLER_2_1028 VPWR VGND sg13g2_fill_1
XFILLER_42_739 VPWR VGND sg13g2_decap_8
XFILLER_2_802 VPWR VGND sg13g2_decap_8
XFILLER_6_607 VPWR VGND sg13g2_decap_8
XFILLER_2_879 VPWR VGND sg13g2_decap_8
Xclkbuf_5_5__f_clk_regs _577_/CLK clkbuf_4_2_0_clk_regs/X VPWR VGND sg13g2_buf_16
XFILLER_14_931 VPWR VGND sg13g2_decap_4
XFILLER_26_791 VPWR VGND sg13g2_decap_8
XFILLER_45_555 VPWR VGND sg13g2_decap_8
X_534_ _534_/Q _534_/CLK _534_/D fanout90/X VPWR VGND sg13g2_dfrbpq_1
X_603_ _603_/Q _657_/CLK _603_/D fanout75/X VPWR VGND sg13g2_dfrbpq_1
X_465_ _653_/D _441_/Y _465_/D fanout77/X VPWR VGND sg13g2_dfrbpq_1
XFILLER_41_750 VPWR VGND sg13g2_decap_8
X_396_ _561_/D _560_/Q _561_/Q _397_/S VPWR VGND sg13g2_mux2_1
XFILLER_5_695 VPWR VGND sg13g2_decap_8
XFILLER_49_861 VPWR VGND sg13g2_decap_8
XFILLER_17_1003 VPWR VGND sg13g2_fill_1
XFILLER_17_791 VPWR VGND sg13g2_decap_8
XFILLER_9_990 VPWR VGND sg13g2_decap_8
XFILLER_11_945 VPWR VGND sg13g2_decap_8
Xfanout42 _374_/S _376_/S VPWR VGND sg13g2_buf_1
Xfanout53 _416_/S _322_/S VPWR VGND sg13g2_buf_1
Xfanout64 fanout64/X fanout65/X VPWR VGND sg13g2_buf_1
Xfanout75 fanout75/X fanout83/X VPWR VGND sg13g2_buf_1
Xfanout97 fanout97/X input1/X VPWR VGND sg13g2_buf_1
Xfanout86 fanout86/X fanout89/X VPWR VGND sg13g2_buf_1
X_250_ _250_/X _631_/Q _252_/B VPWR VGND sg13g2_and2_1
XFILLER_7_905 VPWR VGND sg13g2_decap_8
XFILLER_2_676 VPWR VGND sg13g2_decap_8
XFILLER_6_459 VPWR VGND sg13g2_fill_1
XFILLER_45_352 VPWR VGND sg13g2_decap_8
X_517_ _517_/Q _657_/CLK _517_/D fanout75/X VPWR VGND sg13g2_dfrbpq_1
X_448_ _448_/Y _459_/A _459_/B VPWR VGND sg13g2_xnor2_1
Xclkload12 clkload12/Y _630_/CLK VPWR VGND sg13g2_inv_1
X_379_ _544_/D _543_/Q _544_/Q _391_/S VPWR VGND sg13g2_mux2_1
XFILLER_6_971 VPWR VGND sg13g2_decap_8
XFILLER_5_492 VPWR VGND sg13g2_fill_1
XFILLER_37_820 VPWR VGND sg13g2_decap_4
Xclkload6 clkload6/Y _659_/CLK VPWR VGND sg13g2_inv_1
XFILLER_4_908 VPWR VGND sg13g2_decap_8
XFILLER_8_1001 VPWR VGND sg13g2_fill_2
XFILLER_47_639 VPWR VGND sg13g2_decap_8
X_302_ _471_/D _471_/Q _302_/B VPWR VGND sg13g2_xnor2_1
X_233_ _464_/D _233_/A0 _464_/Q _236_/S VPWR VGND sg13g2_mux2_1
XFILLER_7_779 VPWR VGND sg13g2_decap_8
XFILLER_7_702 VPWR VGND sg13g2_decap_8
XFILLER_2_473 VPWR VGND sg13g2_decap_8
XFILLER_3_941 VPWR VGND sg13g2_decap_8
XFILLER_34_845 VPWR VGND sg13g2_decap_8
XFILLER_46_650 VPWR VGND sg13g2_decap_8
XFILLER_14_1028 VPWR VGND sg13g2_fill_1
XFILLER_25_812 VPWR VGND sg13g2_decap_8
XFILLER_40_837 VPWR VGND sg13g2_decap_8
XFILLER_4_705 VPWR VGND sg13g2_decap_8
XFILLER_0_911 VPWR VGND sg13g2_decap_8
XFILLER_0_988 VPWR VGND sg13g2_decap_8
XFILLER_16_812 VPWR VGND sg13g2_decap_8
XFILLER_47_436 VPWR VGND sg13g2_decap_8
XFILLER_43_631 VPWR VGND sg13g2_decap_8
XFILLER_43_642 VPWR VGND sg13g2_fill_2
XFILLER_43_697 VPWR VGND sg13g2_decap_4
XFILLER_7_576 VPWR VGND sg13g2_decap_8
XFILLER_0_207 VPWR VGND sg13g2_decap_4
XFILLER_0_229 VPWR VGND sg13g2_decap_4
Xoutput19 uio_oe[5] _254_/X VPWR VGND sg13g2_buf_1
XFILLER_44_417 VPWR VGND sg13g2_decap_8
XFILLER_13_837 VPWR VGND sg13g2_decap_8
Xclkbuf_5_20__f_clk_regs _627_/CLK clkbuf_4_10_0_clk_regs/X VPWR VGND sg13g2_buf_16
XFILLER_9_808 VPWR VGND sg13g2_decap_8
XFILLER_4_502 VPWR VGND sg13g2_decap_8
XFILLER_0_785 VPWR VGND sg13g2_decap_8
XFILLER_4_579 VPWR VGND sg13g2_decap_8
XFILLER_48_712 VPWR VGND sg13g2_decap_8
XFILLER_48_789 VPWR VGND sg13g2_decap_8
XFILLER_8_896 VPWR VGND sg13g2_decap_8
XFILLER_7_384 VPWR VGND sg13g2_fill_1
XFILLER_16_0 VPWR VGND sg13g2_fill_1
XFILLER_39_756 VPWR VGND sg13g2_decap_8
XFILLER_1_538 VPWR VGND sg13g2_decap_8
Xclkbuf_5_4__f_clk_regs _652_/CLK clkbuf_4_2_0_clk_regs/X VPWR VGND sg13g2_buf_16
XFILLER_45_737 VPWR VGND sg13g2_decap_8
X_550_ _550_/Q _563_/CLK _550_/D fanout93/X VPWR VGND sg13g2_dfrbpq_1
X_481_ _481_/Q _555_/CLK _481_/D fanout90/X VPWR VGND sg13g2_dfrbpq_1
XFILLER_5_877 VPWR VGND sg13g2_decap_8
XFILLER_5_800 VPWR VGND sg13g2_decap_8
XFILLER_0_582 VPWR VGND sg13g2_decap_8
XFILLER_48_586 VPWR VGND sg13g2_decap_8
Xhold126 _259_/A _643_/Q VPWR VGND sg13g2_dlygate4sd3_1
Xhold115 _615_/D _588_/Q VPWR VGND sg13g2_dlygate4sd3_1
Xhold104 _651_/D _659_/Q VPWR VGND sg13g2_dlygate4sd3_1
XFILLER_42_718 VPWR VGND sg13g2_decap_8
XFILLER_35_770 VPWR VGND sg13g2_decap_8
XFILLER_2_858 VPWR VGND sg13g2_decap_8
X_602_ _602_/Q _652_/CLK _602_/D fanout80/X VPWR VGND sg13g2_dfrbpq_1
XFILLER_14_910 VPWR VGND sg13g2_decap_8
XFILLER_26_770 VPWR VGND sg13g2_decap_8
X_533_ _533_/Q _533_/CLK _533_/D fanout82/X VPWR VGND sg13g2_dfrbpq_1
X_464_ _464_/Q _440_/Y _464_/D fanout78/X VPWR VGND sg13g2_dfrbpq_1
X_395_ _560_/D _559_/Q _560_/Q _398_/S VPWR VGND sg13g2_mux2_1
XFILLER_5_674 VPWR VGND sg13g2_decap_8
XFILLER_4_195 VPWR VGND sg13g2_fill_1
XFILLER_49_840 VPWR VGND sg13g2_decap_8
XFILLER_48_383 VPWR VGND sg13g2_decap_8
XFILLER_17_770 VPWR VGND sg13g2_decap_8
XFILLER_32_784 VPWR VGND sg13g2_decap_8
XFILLER_42_526 VPWR VGND sg13g2_fill_1
XFILLER_11_924 VPWR VGND sg13g2_decap_8
XFILLER_23_795 VPWR VGND sg13g2_decap_8
Xfanout43 _376_/S fanout46/X VPWR VGND sg13g2_buf_1
Xfanout54 _323_/S _322_/S VPWR VGND sg13g2_buf_1
Xfanout65 fanout65/X fanout68/X VPWR VGND sg13g2_buf_1
Xfanout87 fanout87/X fanout88/X VPWR VGND sg13g2_buf_1
Xfanout76 fanout76/X fanout83/X VPWR VGND sg13g2_buf_1
XFILLER_1_121 VPWR VGND sg13g2_fill_1
XFILLER_2_655 VPWR VGND sg13g2_decap_8
XFILLER_14_784 VPWR VGND sg13g2_decap_8
X_516_ _516_/Q _657_/CLK _516_/D fanout75/X VPWR VGND sg13g2_dfrbpq_1
X_447_ _447_/Y _459_/A _459_/B VPWR VGND sg13g2_xnor2_1
X_378_ _543_/D _542_/Q _543_/Q _391_/S VPWR VGND sg13g2_mux2_1
Xclkload13 clkload13/Y _619_/CLK VPWR VGND sg13g2_inv_1
XFILLER_6_950 VPWR VGND sg13g2_decap_8
XFILLER_47_1008 VPWR VGND sg13g2_decap_8
Xclkload7 clkload7/Y _581_/CLK VPWR VGND sg13g2_inv_1
XFILLER_46_106 VPWR VGND sg13g2_fill_1
XFILLER_47_618 VPWR VGND sg13g2_decap_8
XFILLER_43_835 VPWR VGND sg13g2_decap_8
X_301_ _301_/Y _469_/Q _470_/Q _471_/Q _311_/S VPWR VGND sg13g2_nand4_1
X_232_ _236_/S _647_/Q _648_/Q VPWR VGND sg13g2_nand2b_1
XFILLER_11_798 VPWR VGND sg13g2_decap_8
XFILLER_3_920 VPWR VGND sg13g2_decap_8
XFILLER_7_758 VPWR VGND sg13g2_decap_8
XFILLER_2_452 VPWR VGND sg13g2_decap_8
XFILLER_3_997 VPWR VGND sg13g2_decap_8
XFILLER_40_816 VPWR VGND sg13g2_decap_8
XFILLER_0_967 VPWR VGND sg13g2_decap_8
XFILLER_16_868 VPWR VGND sg13g2_decap_4
XFILLER_43_610 VPWR VGND sg13g2_decap_8
XFILLER_47_415 VPWR VGND sg13g2_decap_8
XFILLER_31_805 VPWR VGND sg13g2_fill_2
XFILLER_43_676 VPWR VGND sg13g2_decap_8
XFILLER_7_555 VPWR VGND sg13g2_decap_8
XFILLER_3_794 VPWR VGND sg13g2_decap_8
XFILLER_46_481 VPWR VGND sg13g2_decap_4
Xclkbuf_5_3__f_clk_regs _649_/CLK clkbuf_4_1_0_clk_regs/X VPWR VGND sg13g2_buf_16
XFILLER_13_816 VPWR VGND sg13g2_decap_8
XFILLER_4_558 VPWR VGND sg13g2_decap_8
XFILLER_0_764 VPWR VGND sg13g2_decap_8
XFILLER_48_768 VPWR VGND sg13g2_decap_8
XFILLER_47_256 VPWR VGND sg13g2_fill_1
XFILLER_47_289 VPWR VGND sg13g2_decap_8
XFILLER_12_882 VPWR VGND sg13g2_decap_8
XFILLER_8_875 VPWR VGND sg13g2_decap_8
XFILLER_7_44 VPWR VGND sg13g2_fill_2
XFILLER_7_33 VPWR VGND sg13g2_fill_1
XFILLER_3_591 VPWR VGND sg13g2_decap_8
XFILLER_1_517 VPWR VGND sg13g2_decap_8
XFILLER_45_716 VPWR VGND sg13g2_decap_8
X_480_ _480_/Q _534_/CLK _480_/D fanout90/X VPWR VGND sg13g2_dfrbpq_1
XFILLER_5_856 VPWR VGND sg13g2_decap_8
XFILLER_4_333 VPWR VGND sg13g2_fill_1
XFILLER_0_561 VPWR VGND sg13g2_decap_8
XFILLER_17_941 VPWR VGND sg13g2_fill_2
XFILLER_36_749 VPWR VGND sg13g2_decap_8
XFILLER_48_565 VPWR VGND sg13g2_decap_8
XFILLER_17_985 VPWR VGND sg13g2_decap_8
XFILLER_44_782 VPWR VGND sg13g2_decap_8
Xhold116 _621_/D _592_/Q VPWR VGND sg13g2_dlygate4sd3_1
Xhold105 _650_/D _658_/Q VPWR VGND sg13g2_dlygate4sd3_1
XFILLER_27_749 VPWR VGND sg13g2_decap_8
XFILLER_2_1019 VPWR VGND sg13g2_decap_8
XFILLER_2_837 VPWR VGND sg13g2_decap_8
XFILLER_18_749 VPWR VGND sg13g2_decap_8
X_601_ _601_/Q _616_/CLK _601_/D fanout66/X VPWR VGND sg13g2_dfrbpq_1
XFILLER_49_329 VPWR VGND sg13g2_decap_8
XFILLER_41_785 VPWR VGND sg13g2_decap_8
X_532_ _532_/Q _571_/CLK _532_/D fanout82/X VPWR VGND sg13g2_dfrbpq_1
X_463_ _463_/Q _439_/Y _463_/D fanout78/X VPWR VGND sg13g2_dfrbpq_1
X_394_ _559_/D _558_/Q _559_/Q _397_/S VPWR VGND sg13g2_mux2_1
Xclkbuf_4_6_0_clk_regs clkbuf_4_6_0_clk_regs/X clkbuf_0_clk_regs/X VPWR VGND sg13g2_buf_8
XFILLER_5_653 VPWR VGND sg13g2_decap_8
XFILLER_1_881 VPWR VGND sg13g2_decap_8
XFILLER_4_185 VPWR VGND sg13g2_fill_2
XFILLER_4_174 VPWR VGND sg13g2_decap_8
XFILLER_49_896 VPWR VGND sg13g2_decap_8
XFILLER_48_362 VPWR VGND sg13g2_decap_8
XFILLER_32_763 VPWR VGND sg13g2_decap_8
XFILLER_11_903 VPWR VGND sg13g2_decap_8
XFILLER_23_774 VPWR VGND sg13g2_decap_8
Xfanout44 _429_/S fanout46/X VPWR VGND sg13g2_buf_1
Xfanout55 _322_/S _291_/Y VPWR VGND sg13g2_buf_1
Xfanout66 fanout66/X fanout68/X VPWR VGND sg13g2_buf_1
Xfanout88 fanout88/X fanout89/X VPWR VGND sg13g2_buf_1
Xfanout77 fanout77/X fanout79/X VPWR VGND sg13g2_buf_1
XFILLER_2_634 VPWR VGND sg13g2_decap_8
XFILLER_45_387 VPWR VGND sg13g2_decap_8
X_515_ _515_/Q _515_/CLK _515_/D fanout88/X VPWR VGND sg13g2_dfrbpq_1
XFILLER_46_844 VPWR VGND sg13g2_decap_8
XFILLER_14_763 VPWR VGND sg13g2_decap_8
XFILLER_41_582 VPWR VGND sg13g2_fill_2
X_446_ _446_/Y _459_/A _449_/B VPWR VGND sg13g2_xnor2_1
X_377_ _542_/D _541_/Q _542_/Q _398_/S VPWR VGND sg13g2_mux2_1
XFILLER_10_991 VPWR VGND sg13g2_decap_8
Xclkload14 clkload14/Y _514_/CLK VPWR VGND sg13g2_inv_1
XFILLER_5_483 VPWR VGND sg13g2_decap_8
XFILLER_49_693 VPWR VGND sg13g2_decap_8
XFILLER_20_788 VPWR VGND sg13g2_decap_8
XFILLER_3_409 VPWR VGND sg13g2_fill_2
Xclkload8 clkload8/Y _533_/CLK VPWR VGND sg13g2_inv_1
XFILLER_8_1003 VPWR VGND sg13g2_fill_1
XFILLER_28_811 VPWR VGND sg13g2_decap_8
XFILLER_43_814 VPWR VGND sg13g2_decap_8
X_300_ _470_/D _302_/B _300_/B VPWR VGND sg13g2_and2_1
X_231_ _465_/D _236_/A0 _653_/D _231_/S VPWR VGND sg13g2_mux2_1
XFILLER_11_777 VPWR VGND sg13g2_decap_8
XFILLER_7_737 VPWR VGND sg13g2_decap_8
XFILLER_3_976 VPWR VGND sg13g2_decap_8
XFILLER_14_1019 VPWR VGND sg13g2_decap_8
X_429_ _594_/D _622_/D _594_/Q _429_/S VPWR VGND sg13g2_mux2_1
Xclkbuf_5_2__f_clk_regs _657_/CLK clkbuf_4_1_0_clk_regs/X VPWR VGND sg13g2_buf_16
Xinput1 input1/X rst_n VPWR VGND sg13g2_buf_1
XFILLER_49_490 VPWR VGND sg13g2_decap_8
XFILLER_25_847 VPWR VGND sg13g2_decap_4
XFILLER_0_946 VPWR VGND sg13g2_decap_8
XFILLER_16_847 VPWR VGND sg13g2_decap_8
XFILLER_7_534 VPWR VGND sg13g2_decap_8
XFILLER_3_773 VPWR VGND sg13g2_decap_8
XFILLER_46_460 VPWR VGND sg13g2_decap_8
XFILLER_22_806 VPWR VGND sg13g2_decap_8
XFILLER_30_850 VPWR VGND sg13g2_fill_2
XFILLER_5_1028 VPWR VGND sg13g2_fill_1
XFILLER_5_1017 VPWR VGND sg13g2_decap_8
Xdelaybuf_2_clk delaybuf_2_clk/X clkload0/A VPWR VGND sg13g2_buf_16
XFILLER_4_537 VPWR VGND sg13g2_decap_8
XFILLER_0_743 VPWR VGND sg13g2_decap_8
XFILLER_48_747 VPWR VGND sg13g2_decap_8
XFILLER_12_861 VPWR VGND sg13g2_decap_8
XFILLER_8_854 VPWR VGND sg13g2_decap_8
XFILLER_3_570 VPWR VGND sg13g2_decap_8
XFILLER_10_809 VPWR VGND sg13g2_decap_8
XFILLER_38_791 VPWR VGND sg13g2_decap_8
XFILLER_5_835 VPWR VGND sg13g2_decap_8
XFILLER_0_540 VPWR VGND sg13g2_decap_8
XFILLER_29_791 VPWR VGND sg13g2_decap_8
XFILLER_48_544 VPWR VGND sg13g2_decap_8
XFILLER_44_761 VPWR VGND sg13g2_decap_8
Xhold117 _625_/D _596_/Q VPWR VGND sg13g2_dlygate4sd3_1
Xhold106 _652_/D _660_/Q VPWR VGND sg13g2_dlygate4sd3_1
XFILLER_21_0 VPWR VGND sg13g2_fill_1
XFILLER_2_816 VPWR VGND sg13g2_decap_8
XFILLER_49_308 VPWR VGND sg13g2_decap_8
XFILLER_45_569 VPWR VGND sg13g2_decap_8
X_600_ _600_/Q _623_/CLK _600_/D fanout64/X VPWR VGND sg13g2_dfrbpq_1
X_531_ _531_/Q _659_/CLK _531_/D fanout80/X VPWR VGND sg13g2_dfrbpq_1
XFILLER_41_764 VPWR VGND sg13g2_decap_8
X_462_ _658_/D _438_/Y _462_/D fanout78/X VPWR VGND sg13g2_dfrbpq_1
X_393_ _558_/D _557_/Q _558_/Q _397_/S VPWR VGND sg13g2_mux2_1
XFILLER_5_632 VPWR VGND sg13g2_decap_8
XFILLER_4_164 VPWR VGND sg13g2_fill_2
XFILLER_1_860 VPWR VGND sg13g2_decap_8
XFILLER_49_875 VPWR VGND sg13g2_decap_8
XFILLER_48_341 VPWR VGND sg13g2_decap_8
XFILLER_11_959 VPWR VGND sg13g2_decap_8
XFILLER_13_33 VPWR VGND sg13g2_fill_2
Xfanout45 _428_/S fanout46/X VPWR VGND sg13g2_buf_1
Xfanout56 _397_/S _398_/S VPWR VGND sg13g2_buf_1
Xfanout67 fanout67/X fanout68/X VPWR VGND sg13g2_buf_1
Xfanout89 fanout89/X fanout91/X VPWR VGND sg13g2_buf_1
Xfanout78 fanout78/X fanout79/X VPWR VGND sg13g2_buf_1
XFILLER_2_613 VPWR VGND sg13g2_decap_8
XFILLER_7_919 VPWR VGND sg13g2_decap_8
XFILLER_45_311 VPWR VGND sg13g2_decap_8
XFILLER_45_366 VPWR VGND sg13g2_decap_8
X_514_ _514_/Q _514_/CLK _514_/D fanout87/X VPWR VGND sg13g2_dfrbpq_1
XFILLER_46_823 VPWR VGND sg13g2_decap_8
XFILLER_10_970 VPWR VGND sg13g2_decap_8
Xclkload15 clkload15/Y _621_/CLK VPWR VGND sg13g2_inv_1
X_445_ _445_/Y _456_/A _452_/B VPWR VGND sg13g2_xnor2_1
X_376_ _541_/D _540_/Q _541_/Q _376_/S VPWR VGND sg13g2_mux2_1
Xclkbuf_5_1__f_clk_regs _541_/CLK clkbuf_4_0_0_clk_regs/X VPWR VGND sg13g2_buf_16
XFILLER_6_985 VPWR VGND sg13g2_decap_8
XFILLER_49_672 VPWR VGND sg13g2_decap_8
Xclkload9 clkload9/Y _567_/CLK VPWR VGND sg13g2_inv_1
XFILLER_42_303 VPWR VGND sg13g2_fill_2
XFILLER_11_756 VPWR VGND sg13g2_decap_8
Xclkbuf_1_1__f__017__regs _461_/CLK clkbuf_0__017__regs/X VPWR VGND sg13g2_buf_16
X_230_ _466_/D _235_/A0 _466_/Q _231_/S VPWR VGND sg13g2_mux2_1
XFILLER_7_716 VPWR VGND sg13g2_decap_8
XFILLER_3_955 VPWR VGND sg13g2_decap_8
XFILLER_19_812 VPWR VGND sg13g2_decap_8
XFILLER_19_823 VPWR VGND sg13g2_fill_2
XFILLER_2_487 VPWR VGND sg13g2_decap_8
X_428_ _593_/D _592_/Q _622_/D _428_/S VPWR VGND sg13g2_mux2_1
XFILLER_46_697 VPWR VGND sg13g2_decap_8
XFILLER_46_664 VPWR VGND sg13g2_decap_8
X_359_ _524_/D _523_/Q _524_/Q _374_/S VPWR VGND sg13g2_mux2_1
XFILLER_6_782 VPWR VGND sg13g2_decap_8
XFILLER_25_826 VPWR VGND sg13g2_decap_8
Xinput2 _291_/B ui_in[0] VPWR VGND sg13g2_buf_1
XFILLER_3_218 VPWR VGND sg13g2_fill_1
XFILLER_3_229 VPWR VGND sg13g2_decap_8
XFILLER_4_719 VPWR VGND sg13g2_decap_8
XFILLER_0_925 VPWR VGND sg13g2_decap_8
XFILLER_48_929 VPWR VGND sg13g2_fill_2
XFILLER_16_826 VPWR VGND sg13g2_decap_8
XFILLER_3_752 VPWR VGND sg13g2_decap_8
XFILLER_21_851 VPWR VGND sg13g2_fill_1
XFILLER_4_516 VPWR VGND sg13g2_decap_8
XFILLER_0_722 VPWR VGND sg13g2_decap_8
XFILLER_0_799 VPWR VGND sg13g2_decap_8
XFILLER_48_726 VPWR VGND sg13g2_decap_8
XFILLER_12_840 VPWR VGND sg13g2_decap_8
XFILLER_43_453 VPWR VGND sg13g2_decap_8
XFILLER_43_464 VPWR VGND sg13g2_fill_1
XFILLER_8_833 VPWR VGND sg13g2_decap_8
XFILLER_7_46 VPWR VGND sg13g2_fill_1
XFILLER_7_332 VPWR VGND sg13g2_decap_8
XFILLER_38_770 VPWR VGND sg13g2_decap_8
XFILLER_10_1012 VPWR VGND sg13g2_decap_8
XFILLER_5_814 VPWR VGND sg13g2_decap_8
XFILLER_0_596 VPWR VGND sg13g2_decap_8
XFILLER_4_368 VPWR VGND sg13g2_fill_2
XFILLER_48_523 VPWR VGND sg13g2_decap_8
XFILLER_17_943 VPWR VGND sg13g2_fill_1
XFILLER_29_770 VPWR VGND sg13g2_decap_8
XFILLER_44_740 VPWR VGND sg13g2_decap_8
Xhold118 _607_/D _580_/Q VPWR VGND sg13g2_dlygate4sd3_1
Xhold107 _649_/D _657_/Q VPWR VGND sg13g2_dlygate4sd3_1
XFILLER_4_880 VPWR VGND sg13g2_decap_8
XFILLER_14_0 VPWR VGND sg13g2_fill_2
XFILLER_35_784 VPWR VGND sg13g2_decap_4
XFILLER_1_327 VPWR VGND sg13g2_fill_2
XFILLER_14_924 VPWR VGND sg13g2_decap_8
XFILLER_26_784 VPWR VGND sg13g2_decap_8
XFILLER_45_548 VPWR VGND sg13g2_decap_8
X_530_ _530_/Q _657_/CLK _530_/D fanout75/X VPWR VGND sg13g2_dfrbpq_1
X_461_ _461_/Q _461_/CLK _461_/D fanout77/X VPWR VGND sg13g2_dfrbpq_1
XFILLER_14_979 VPWR VGND sg13g2_decap_4
XFILLER_41_743 VPWR VGND sg13g2_decap_8
X_392_ _557_/D _556_/Q _557_/Q _392_/S VPWR VGND sg13g2_mux2_1
Xclkbuf_5_0__f_clk_regs _656_/CLK clkbuf_4_0_0_clk_regs/X VPWR VGND sg13g2_buf_16
XFILLER_5_688 VPWR VGND sg13g2_decap_8
XFILLER_5_611 VPWR VGND sg13g2_decap_8
XFILLER_0_382 VPWR VGND sg13g2_decap_8
XFILLER_0_393 VPWR VGND sg13g2_fill_1
XFILLER_49_854 VPWR VGND sg13g2_decap_8
XFILLER_48_320 VPWR VGND sg13g2_decap_8
XFILLER_17_784 VPWR VGND sg13g2_decap_8
XFILLER_1_1021 VPWR VGND sg13g2_decap_8
X_659_ _659_/Q _659_/CLK _659_/D fanout79/X VPWR VGND sg13g2_dfrbpq_1
XFILLER_48_397 VPWR VGND sg13g2_decap_8
XFILLER_32_798 VPWR VGND sg13g2_decap_4
XFILLER_9_983 VPWR VGND sg13g2_decap_8
XFILLER_11_938 VPWR VGND sg13g2_decap_8
Xfanout46 fanout46/X _322_/S VPWR VGND sg13g2_buf_1
Xfanout57 _398_/S _392_/S VPWR VGND sg13g2_buf_1
Xfanout68 fanout68/X fanout74/X VPWR VGND sg13g2_buf_1
Xfanout79 fanout79/X fanout80/X VPWR VGND sg13g2_buf_1
XFILLER_6_419 VPWR VGND sg13g2_decap_4
XFILLER_2_669 VPWR VGND sg13g2_decap_8
XFILLER_46_802 VPWR VGND sg13g2_decap_8
XFILLER_45_345 VPWR VGND sg13g2_decap_8
X_513_ _513_/Q _514_/CLK _513_/D fanout87/X VPWR VGND sg13g2_dfrbpq_1
X_444_ _444_/Y _444_/A _444_/B VPWR VGND sg13g2_xnor2_1
XFILLER_14_798 VPWR VGND sg13g2_decap_8
XFILLER_41_584 VPWR VGND sg13g2_fill_1
Xclkload16 clkload16/Y _563_/CLK VPWR VGND sg13g2_inv_1
X_375_ _540_/D _539_/Q _540_/Q _376_/S VPWR VGND sg13g2_mux2_1
XFILLER_6_964 VPWR VGND sg13g2_decap_8
XFILLER_37_813 VPWR VGND sg13g2_decap_8
XFILLER_37_824 VPWR VGND sg13g2_fill_1
XFILLER_49_651 VPWR VGND sg13g2_decap_8
XFILLER_9_780 VPWR VGND sg13g2_decap_8
XFILLER_24_33 VPWR VGND sg13g2_fill_1
XFILLER_43_849 VPWR VGND sg13g2_fill_2
XFILLER_2_466 VPWR VGND sg13g2_decap_8
XFILLER_3_934 VPWR VGND sg13g2_decap_8
XFILLER_46_643 VPWR VGND sg13g2_decap_8
X_427_ _592_/D _591_/Q _592_/Q _428_/S VPWR VGND sg13g2_mux2_1
X_358_ _523_/D _522_/Q _523_/Q _374_/S VPWR VGND sg13g2_mux2_1
X_289_ _289_/Y _226_/Y _258_/A _288_/Y VPWR VGND sg13g2_o21ai_1
XFILLER_6_761 VPWR VGND sg13g2_decap_8
Xdelaybuf_21_clk delaybuf_22_clk/A delaybuf_21_clk/A VPWR VGND sg13g2_buf_16
XFILLER_25_805 VPWR VGND sg13g2_decap_8
Xinput3 input3/X ui_in[1] VPWR VGND sg13g2_buf_1
XFILLER_0_904 VPWR VGND sg13g2_decap_8
XFILLER_3_208 VPWR VGND sg13g2_fill_1
XFILLER_16_805 VPWR VGND sg13g2_decap_8
Xdelaybuf_12_clk delaybuf_13_clk/A delaybuf_12_clk/A VPWR VGND sg13g2_buf_16
XFILLER_47_429 VPWR VGND sg13g2_decap_8
XFILLER_43_624 VPWR VGND sg13g2_decap_8
XFILLER_3_731 VPWR VGND sg13g2_decap_8
XFILLER_7_569 VPWR VGND sg13g2_decap_8
XFILLER_15_882 VPWR VGND sg13g2_decap_8
Xclkbuf_1_0__f__017_ _258_/B clkbuf_0__017_/X VPWR VGND sg13g2_buf_16
XFILLER_0_701 VPWR VGND sg13g2_decap_8
XFILLER_0_778 VPWR VGND sg13g2_decap_8
XFILLER_48_705 VPWR VGND sg13g2_decap_8
XFILLER_12_896 VPWR VGND sg13g2_decap_8
XFILLER_8_812 VPWR VGND sg13g2_decap_8
XFILLER_8_889 VPWR VGND sg13g2_decap_8
XFILLER_39_749 VPWR VGND sg13g2_decap_8
XFILLER_46_292 VPWR VGND sg13g2_decap_8
XFILLER_47_793 VPWR VGND sg13g2_decap_8
XFILLER_0_575 VPWR VGND sg13g2_decap_8
XFILLER_48_579 VPWR VGND sg13g2_decap_8
XFILLER_48_502 VPWR VGND sg13g2_decap_8
XFILLER_17_999 VPWR VGND sg13g2_decap_4
XFILLER_44_796 VPWR VGND sg13g2_decap_8
Xhold108 _630_/D _601_/Q VPWR VGND sg13g2_dlygate4sd3_1
Xhold119 _611_/D _584_/Q VPWR VGND sg13g2_dlygate4sd3_1
XFILLER_47_590 VPWR VGND sg13g2_decap_8
XFILLER_35_763 VPWR VGND sg13g2_decap_8
XFILLER_14_903 VPWR VGND sg13g2_decap_8
XFILLER_26_763 VPWR VGND sg13g2_decap_8
XFILLER_41_722 VPWR VGND sg13g2_decap_8
X_460_ _460_/Y _460_/A _460_/B VPWR VGND sg13g2_xnor2_1
X_391_ _556_/D _555_/Q _556_/Q _391_/S VPWR VGND sg13g2_mux2_1
XFILLER_41_799 VPWR VGND sg13g2_decap_8
XFILLER_5_667 VPWR VGND sg13g2_decap_8
XFILLER_0_361 VPWR VGND sg13g2_decap_8
XFILLER_1_1000 VPWR VGND sg13g2_decap_8
XFILLER_1_895 VPWR VGND sg13g2_decap_8
XFILLER_49_833 VPWR VGND sg13g2_decap_8
XFILLER_48_376 VPWR VGND sg13g2_decap_8
XFILLER_17_763 VPWR VGND sg13g2_decap_8
XFILLER_32_777 VPWR VGND sg13g2_decap_8
XFILLER_44_593 VPWR VGND sg13g2_decap_8
X_589_ _616_/D _630_/CLK _589_/D fanout67/X VPWR VGND sg13g2_dfrbpq_1
X_658_ _658_/Q _660_/CLK _658_/D fanout78/X VPWR VGND sg13g2_dfrbpq_1
XFILLER_13_991 VPWR VGND sg13g2_decap_8
XFILLER_9_962 VPWR VGND sg13g2_decap_8
XFILLER_11_917 VPWR VGND sg13g2_decap_8
XFILLER_13_35 VPWR VGND sg13g2_fill_1
XFILLER_13_46 VPWR VGND sg13g2_fill_2
XFILLER_23_788 VPWR VGND sg13g2_decap_8
Xfanout47 _412_/S _366_/S VPWR VGND sg13g2_buf_1
Xfanout58 _405_/S _391_/S VPWR VGND sg13g2_buf_1
Xfanout69 fanout69/X fanout74/X VPWR VGND sg13g2_buf_1
XFILLER_2_648 VPWR VGND sg13g2_decap_8
XFILLER_14_777 VPWR VGND sg13g2_decap_8
X_512_ _512_/Q _607_/CLK _512_/D fanout87/X VPWR VGND sg13g2_dfrbpq_1
X_443_ _443_/Y _444_/A _444_/B VPWR VGND sg13g2_xnor2_1
X_374_ _539_/D _538_/Q _539_/Q _374_/S VPWR VGND sg13g2_mux2_1
Xclkload17 clkload17/Y _461_/CLK VPWR VGND sg13g2_inv_1
XFILLER_6_943 VPWR VGND sg13g2_decap_8
XFILLER_1_692 VPWR VGND sg13g2_decap_8
XFILLER_49_630 VPWR VGND sg13g2_decap_8
Xclkbuf_leaf_0_clk _459_/B delaybuf_2_clk/X VPWR VGND sg13g2_buf_8
Xclkbuf_4_5_0_clk_regs clkbuf_4_5_0_clk_regs/X clkbuf_0_clk_regs/X VPWR VGND sg13g2_buf_8
XFILLER_43_828 VPWR VGND sg13g2_decap_8
XFILLER_3_913 VPWR VGND sg13g2_decap_8
XFILLER_6_228 VPWR VGND sg13g2_fill_1
XFILLER_2_445 VPWR VGND sg13g2_decap_8
XFILLER_45_132 VPWR VGND sg13g2_fill_1
XFILLER_46_622 VPWR VGND sg13g2_decap_8
X_426_ _591_/D _590_/Q _591_/Q _428_/S VPWR VGND sg13g2_mux2_1
X_357_ _522_/D _521_/Q _522_/Q _412_/S VPWR VGND sg13g2_mux2_1
X_288_ _288_/Y _288_/A1 _279_/Y _281_/Y _288_/B2 VPWR VGND sg13g2_a22oi_1
XFILLER_6_740 VPWR VGND sg13g2_decap_8
XFILLER_5_272 VPWR VGND sg13g2_fill_2
Xinput4 _281_/A ui_in[2] VPWR VGND sg13g2_buf_1
XFILLER_40_809 VPWR VGND sg13g2_decap_8
XFILLER_43_603 VPWR VGND sg13g2_decap_8
XFILLER_47_408 VPWR VGND sg13g2_decap_8
XFILLER_43_669 VPWR VGND sg13g2_decap_8
XFILLER_3_710 VPWR VGND sg13g2_decap_8
Xdelaybuf_5_clk delaybuf_6_clk/A delaybuf_5_clk/A VPWR VGND sg13g2_buf_16
XFILLER_7_548 VPWR VGND sg13g2_decap_8
XFILLER_4_0 VPWR VGND sg13g2_fill_1
XFILLER_2_264 VPWR VGND sg13g2_decap_4
XFILLER_3_787 VPWR VGND sg13g2_decap_8
XFILLER_15_861 VPWR VGND sg13g2_decap_8
XFILLER_47_964 VPWR VGND sg13g2_decap_4
XFILLER_46_485 VPWR VGND sg13g2_fill_2
XFILLER_46_474 VPWR VGND sg13g2_decap_8
X_409_ _574_/D _573_/Q _574_/Q _412_/S VPWR VGND sg13g2_mux2_1
XFILLER_13_809 VPWR VGND sg13g2_decap_8
XFILLER_0_757 VPWR VGND sg13g2_decap_8
XFILLER_12_875 VPWR VGND sg13g2_decap_8
XFILLER_8_868 VPWR VGND sg13g2_decap_8
XFILLER_7_301 VPWR VGND sg13g2_decap_8
XFILLER_3_584 VPWR VGND sg13g2_decap_8
XFILLER_4_1020 VPWR VGND sg13g2_decap_8
XFILLER_47_772 VPWR VGND sg13g2_decap_8
XFILLER_46_271 VPWR VGND sg13g2_decap_8
XFILLER_45_709 VPWR VGND sg13g2_decap_8
XFILLER_5_849 VPWR VGND sg13g2_decap_8
XFILLER_0_554 VPWR VGND sg13g2_decap_8
XFILLER_48_558 VPWR VGND sg13g2_decap_8
XFILLER_17_934 VPWR VGND sg13g2_decap_8
XFILLER_17_978 VPWR VGND sg13g2_decap_8
XFILLER_43_252 VPWR VGND sg13g2_fill_2
XFILLER_44_775 VPWR VGND sg13g2_decap_8
Xhold109 _659_/D _463_/Q VPWR VGND sg13g2_dlygate4sd3_1
XFILLER_7_175 VPWR VGND sg13g2_fill_1
XFILLER_41_701 VPWR VGND sg13g2_decap_8
X_390_ _555_/D _554_/Q _555_/Q _391_/S VPWR VGND sg13g2_mux2_1
XFILLER_41_778 VPWR VGND sg13g2_decap_8
XFILLER_5_646 VPWR VGND sg13g2_decap_8
XFILLER_1_874 VPWR VGND sg13g2_decap_8
XFILLER_49_812 VPWR VGND sg13g2_decap_8
X_657_ _657_/Q _657_/CLK _657_/D fanout79/X VPWR VGND sg13g2_dfrbpq_1
XFILLER_49_889 VPWR VGND sg13g2_decap_8
XFILLER_48_355 VPWR VGND sg13g2_decap_8
XFILLER_13_970 VPWR VGND sg13g2_decap_8
XFILLER_32_756 VPWR VGND sg13g2_decap_8
XFILLER_44_572 VPWR VGND sg13g2_decap_8
X_588_ _588_/Q _630_/CLK _588_/D fanout66/X VPWR VGND sg13g2_dfrbpq_1
XFILLER_9_941 VPWR VGND sg13g2_decap_8
XFILLER_23_756 VPWR VGND sg13g2_decap_8
XFILLER_23_767 VPWR VGND sg13g2_decap_8
Xfanout48 _407_/S _366_/S VPWR VGND sg13g2_buf_1
Xfanout59 _391_/S _392_/S VPWR VGND sg13g2_buf_1
XFILLER_1_159 VPWR VGND sg13g2_decap_4
XFILLER_2_627 VPWR VGND sg13g2_decap_8
XFILLER_45_325 VPWR VGND sg13g2_fill_1
X_511_ _511_/Q _581_/CLK _511_/D fanout89/X VPWR VGND sg13g2_dfrbpq_1
XFILLER_46_837 VPWR VGND sg13g2_decap_8
XFILLER_14_756 VPWR VGND sg13g2_decap_8
XFILLER_16_1020 VPWR VGND sg13g2_decap_8
XFILLER_41_575 VPWR VGND sg13g2_decap_8
X_442_ _442_/Y _460_/A _460_/B VPWR VGND sg13g2_xnor2_1
X_373_ _538_/D _537_/Q _538_/Q _374_/S VPWR VGND sg13g2_mux2_1
XFILLER_10_984 VPWR VGND sg13g2_decap_8
Xclkload18 clkload18/X _460_/A VPWR VGND sg13g2_buf_8
XFILLER_6_999 VPWR VGND sg13g2_decap_8
XFILLER_6_922 VPWR VGND sg13g2_decap_8
XFILLER_1_671 VPWR VGND sg13g2_decap_8
XFILLER_49_686 VPWR VGND sg13g2_decap_8
XFILLER_28_804 VPWR VGND sg13g2_decap_8
XFILLER_43_807 VPWR VGND sg13g2_decap_8
XFILLER_3_969 VPWR VGND sg13g2_decap_8
XFILLER_6_4 VPWR VGND sg13g2_fill_2
XFILLER_46_601 VPWR VGND sg13g2_decap_8
XFILLER_46_678 VPWR VGND sg13g2_decap_4
XFILLER_10_781 VPWR VGND sg13g2_decap_8
XFILLER_42_851 VPWR VGND sg13g2_fill_1
X_425_ _590_/D _616_/D _590_/Q _429_/S VPWR VGND sg13g2_mux2_1
X_356_ _521_/D _520_/Q _521_/Q _407_/S VPWR VGND sg13g2_mux2_1
X_287_ _287_/Y _225_/Y _258_/A _286_/Y VPWR VGND sg13g2_o21ai_1
XFILLER_6_796 VPWR VGND sg13g2_decap_8
XFILLER_2_991 VPWR VGND sg13g2_decap_8
Xinput5 _279_/B ui_in[3] VPWR VGND sg13g2_buf_1
XFILLER_49_483 VPWR VGND sg13g2_decap_8
XFILLER_10_26 VPWR VGND sg13g2_fill_2
XFILLER_0_939 VPWR VGND sg13g2_decap_8
XFILLER_24_840 VPWR VGND sg13g2_decap_8
XFILLER_13_1012 VPWR VGND sg13g2_decap_8
XFILLER_24_851 VPWR VGND sg13g2_fill_1
XFILLER_3_766 VPWR VGND sg13g2_decap_8
XFILLER_15_840 VPWR VGND sg13g2_decap_8
X_408_ _573_/D _572_/Q _573_/Q _412_/S VPWR VGND sg13g2_mux2_1
XFILLER_46_453 VPWR VGND sg13g2_decap_8
X_339_ _504_/D _503_/Q _504_/Q _415_/S VPWR VGND sg13g2_mux2_1
XFILLER_6_593 VPWR VGND sg13g2_decap_8
X_257__98 _648_/CLK _257__99/A VPWR VGND sg13g2_inv_1
XFILLER_0_736 VPWR VGND sg13g2_decap_8
XFILLER_43_412 VPWR VGND sg13g2_decap_8
XFILLER_12_854 VPWR VGND sg13g2_decap_8
XFILLER_8_847 VPWR VGND sg13g2_decap_8
XFILLER_7_346 VPWR VGND sg13g2_fill_1
XFILLER_3_563 VPWR VGND sg13g2_decap_8
XFILLER_47_751 VPWR VGND sg13g2_decap_8
XFILLER_7_891 VPWR VGND sg13g2_decap_8
XFILLER_38_784 VPWR VGND sg13g2_decap_8
XFILLER_5_828 VPWR VGND sg13g2_decap_8
XFILLER_0_533 VPWR VGND sg13g2_decap_8
XFILLER_10_1026 VPWR VGND sg13g2_fill_2
XFILLER_29_784 VPWR VGND sg13g2_decap_8
XFILLER_48_537 VPWR VGND sg13g2_decap_8
XFILLER_44_754 VPWR VGND sg13g2_decap_8
XFILLER_7_110 VPWR VGND sg13g2_decap_4
XFILLER_4_894 VPWR VGND sg13g2_decap_8
XFILLER_2_809 VPWR VGND sg13g2_decap_8
XFILLER_26_798 VPWR VGND sg13g2_decap_8
XFILLER_41_757 VPWR VGND sg13g2_decap_8
XFILLER_5_625 VPWR VGND sg13g2_decap_8
XFILLER_4_113 VPWR VGND sg13g2_fill_1
XFILLER_49_1011 VPWR VGND sg13g2_decap_8
XFILLER_1_853 VPWR VGND sg13g2_decap_8
XFILLER_49_868 VPWR VGND sg13g2_decap_8
XFILLER_48_334 VPWR VGND sg13g2_decap_8
XFILLER_17_798 VPWR VGND sg13g2_decap_8
XFILLER_44_551 VPWR VGND sg13g2_decap_8
X_587_ _587_/Q _616_/CLK _587_/D fanout64/X VPWR VGND sg13g2_dfrbpq_1
X_656_ _656_/Q _656_/CLK _656_/D fanout70/X VPWR VGND sg13g2_dfrbpq_1
XFILLER_9_997 VPWR VGND sg13g2_decap_8
XFILLER_9_920 VPWR VGND sg13g2_decap_8
XFILLER_4_691 VPWR VGND sg13g2_decap_8
Xfanout38 _278_/S _270_/S VPWR VGND sg13g2_buf_1
Xfanout49 _366_/S _322_/S VPWR VGND sg13g2_buf_1
XFILLER_2_606 VPWR VGND sg13g2_decap_8
Xclkbuf_5_31__f_clk_regs _561_/CLK clkbuf_4_15_0_clk_regs/X VPWR VGND sg13g2_buf_16
XFILLER_45_359 VPWR VGND sg13g2_decap_8
X_510_ _510_/Q _541_/CLK _510_/D fanout84/X VPWR VGND sg13g2_dfrbpq_1
X_441_ _441_/Y _444_/A _444_/B VPWR VGND sg13g2_xnor2_1
XFILLER_46_816 VPWR VGND sg13g2_decap_8
XFILLER_10_963 VPWR VGND sg13g2_decap_8
X_372_ _537_/D _536_/Q _537_/Q _429_/S VPWR VGND sg13g2_mux2_1
XFILLER_6_901 VPWR VGND sg13g2_decap_8
Xclkload19 clkload19/Y _456_/A VPWR VGND sg13g2_inv_2
XFILLER_6_978 VPWR VGND sg13g2_decap_8
XFILLER_5_444 VPWR VGND sg13g2_fill_2
XFILLER_0_193 VPWR VGND sg13g2_decap_8
XFILLER_1_650 VPWR VGND sg13g2_decap_8
XFILLER_49_665 VPWR VGND sg13g2_decap_8
X_639_ _639_/Q _453_/Y _639_/D fanout73/X VPWR VGND sg13g2_dfrbpq_1
XFILLER_9_794 VPWR VGND sg13g2_decap_8
Xdelaybuf_24_clk delaybuf_25_clk/A delaybuf_24_clk/A VPWR VGND sg13g2_buf_16
XFILLER_11_749 VPWR VGND sg13g2_decap_8
XFILLER_7_709 VPWR VGND sg13g2_decap_8
XFILLER_3_948 VPWR VGND sg13g2_decap_8
Xdelaybuf_15_clk delaybuf_16_clk/A delaybuf_15_clk/A VPWR VGND sg13g2_buf_16
XFILLER_19_805 VPWR VGND sg13g2_decap_8
XFILLER_42_830 VPWR VGND sg13g2_decap_8
X_424_ _589_/D _588_/Q _616_/D _432_/S VPWR VGND sg13g2_mux2_1
XFILLER_46_657 VPWR VGND sg13g2_decap_8
X_355_ _520_/D _519_/Q _520_/Q _407_/S VPWR VGND sg13g2_mux2_1
X_286_ _286_/Y _286_/A1 _279_/Y _281_/Y _286_/B2 VPWR VGND sg13g2_a22oi_1
XFILLER_2_970 VPWR VGND sg13g2_decap_8
XFILLER_6_775 VPWR VGND sg13g2_decap_8
XFILLER_25_819 VPWR VGND sg13g2_decap_8
Xinput6 _603_/D ui_in[4] VPWR VGND sg13g2_buf_1
XFILLER_49_462 VPWR VGND sg13g2_decap_8
XFILLER_33_841 VPWR VGND sg13g2_decap_8
XFILLER_0_918 VPWR VGND sg13g2_decap_8
XFILLER_16_819 VPWR VGND sg13g2_decap_8
XFILLER_43_638 VPWR VGND sg13g2_decap_4
XFILLER_3_745 VPWR VGND sg13g2_decap_8
Xclkbuf_2_2__f_clk_delayed _456_/A clkbuf_0_clk_delayed/X VPWR VGND sg13g2_buf_16
XFILLER_46_432 VPWR VGND sg13g2_decap_8
XFILLER_15_896 VPWR VGND sg13g2_decap_8
X_407_ _572_/D _571_/Q _572_/Q _407_/S VPWR VGND sg13g2_mux2_1
X_338_ _503_/D _502_/Q _503_/Q _415_/S VPWR VGND sg13g2_mux2_1
X_269_ _641_/D _607_/Q _621_/Q _270_/S VPWR VGND sg13g2_mux2_1
XFILLER_6_572 VPWR VGND sg13g2_decap_8
XFILLER_2_72 VPWR VGND sg13g2_fill_1
XFILLER_21_822 VPWR VGND sg13g2_decap_8
XFILLER_21_833 VPWR VGND sg13g2_fill_1
XFILLER_21_844 VPWR VGND sg13g2_decap_8
XFILLER_0_715 VPWR VGND sg13g2_decap_8
X_257__99 _647_/CLK _257__99/A VPWR VGND sg13g2_inv_1
XFILLER_4_509 VPWR VGND sg13g2_decap_8
XFILLER_48_719 VPWR VGND sg13g2_decap_8
XFILLER_12_833 VPWR VGND sg13g2_decap_8
XFILLER_8_826 VPWR VGND sg13g2_decap_8
XFILLER_7_325 VPWR VGND sg13g2_decap_8
XFILLER_3_542 VPWR VGND sg13g2_decap_8
XFILLER_47_730 VPWR VGND sg13g2_decap_8
XFILLER_7_870 VPWR VGND sg13g2_decap_8
XFILLER_38_763 VPWR VGND sg13g2_decap_8
XFILLER_10_1005 VPWR VGND sg13g2_decap_8
XFILLER_5_807 VPWR VGND sg13g2_decap_8
XFILLER_0_512 VPWR VGND sg13g2_decap_8
XFILLER_0_589 VPWR VGND sg13g2_decap_8
XFILLER_48_516 VPWR VGND sg13g2_decap_8
XFILLER_29_763 VPWR VGND sg13g2_decap_8
XFILLER_44_733 VPWR VGND sg13g2_decap_8
XFILLER_4_873 VPWR VGND sg13g2_decap_8
XFILLER_35_777 VPWR VGND sg13g2_decap_8
XFILLER_35_788 VPWR VGND sg13g2_fill_1
XFILLER_35_799 VPWR VGND sg13g2_decap_8
Xclkbuf_5_30__f_clk_regs _562_/CLK clkbuf_4_15_0_clk_regs/X VPWR VGND sg13g2_buf_16
XFILLER_14_917 VPWR VGND sg13g2_decap_8
XFILLER_26_777 VPWR VGND sg13g2_decap_8
XFILLER_41_736 VPWR VGND sg13g2_decap_8
XFILLER_5_604 VPWR VGND sg13g2_decap_8
XFILLER_1_832 VPWR VGND sg13g2_decap_8
XFILLER_49_847 VPWR VGND sg13g2_decap_8
XFILLER_48_313 VPWR VGND sg13g2_decap_8
XFILLER_17_777 VPWR VGND sg13g2_decap_8
XFILLER_1_1014 VPWR VGND sg13g2_decap_8
X_586_ _586_/Q _628_/CLK _586_/D fanout64/X VPWR VGND sg13g2_dfrbpq_1
X_655_ _655_/Q _656_/CLK _655_/D fanout75/X VPWR VGND sg13g2_dfrbpq_1
XFILLER_9_976 VPWR VGND sg13g2_decap_8
XFILLER_3_180 VPWR VGND sg13g2_fill_1
Xclkbuf_leaf_3_clk _440_/B clkload0/A VPWR VGND sg13g2_buf_8
XFILLER_4_670 VPWR VGND sg13g2_decap_8
XFILLER_48_880 VPWR VGND sg13g2_decap_8
Xfanout39 _270_/S hold102/X VPWR VGND sg13g2_buf_1
XFILLER_31_791 VPWR VGND sg13g2_decap_8
XFILLER_45_305 VPWR VGND sg13g2_fill_2
X_440_ _440_/Y _444_/A _440_/B VPWR VGND sg13g2_xnor2_1
X_371_ _536_/D _535_/Q _536_/Q _429_/S VPWR VGND sg13g2_mux2_1
XFILLER_10_942 VPWR VGND sg13g2_decap_8
XFILLER_6_957 VPWR VGND sg13g2_decap_8
XFILLER_0_172 VPWR VGND sg13g2_decap_8
XFILLER_37_806 VPWR VGND sg13g2_decap_8
XFILLER_49_644 VPWR VGND sg13g2_decap_8
XFILLER_44_382 VPWR VGND sg13g2_decap_8
X_569_ _569_/Q _570_/CLK _569_/D fanout94/X VPWR VGND sg13g2_dfrbpq_1
X_638_ _638_/Q _452_/Y _638_/D fanout67/X VPWR VGND sg13g2_dfrbpq_1
XFILLER_9_773 VPWR VGND sg13g2_decap_8
XFILLER_36_850 VPWR VGND sg13g2_fill_2
XFILLER_2_459 VPWR VGND sg13g2_decap_8
XFILLER_3_927 VPWR VGND sg13g2_decap_8
XFILLER_46_636 VPWR VGND sg13g2_decap_8
XFILLER_27_850 VPWR VGND sg13g2_fill_2
XFILLER_41_363 VPWR VGND sg13g2_decap_4
X_423_ _588_/D _587_/Q _588_/Q _432_/S VPWR VGND sg13g2_mux2_1
X_354_ _519_/D _518_/Q _519_/Q _412_/S VPWR VGND sg13g2_mux2_1
Xdelaybuf_8_clk delaybuf_9_clk/A delaybuf_8_clk/A VPWR VGND sg13g2_buf_16
X_285_ _285_/Y _224_/Y _258_/A _284_/Y VPWR VGND sg13g2_o21ai_1
XFILLER_6_754 VPWR VGND sg13g2_decap_8
XFILLER_5_242 VPWR VGND sg13g2_decap_4
XFILLER_49_441 VPWR VGND sg13g2_decap_8
Xinput7 _604_/D ui_in[5] VPWR VGND sg13g2_buf_1
XFILLER_42_138 VPWR VGND sg13g2_fill_1
XFILLER_43_617 VPWR VGND sg13g2_decap_8
XFILLER_7_507 VPWR VGND sg13g2_fill_2
XFILLER_3_724 VPWR VGND sg13g2_decap_8
XFILLER_46_411 VPWR VGND sg13g2_decap_8
XFILLER_30_812 VPWR VGND sg13g2_decap_8
XFILLER_42_650 VPWR VGND sg13g2_fill_1
Xclkbuf_4_4_0_clk_regs clkbuf_4_4_0_clk_regs/X clkbuf_0_clk_regs/X VPWR VGND sg13g2_buf_8
X_406_ _571_/D _570_/Q _571_/Q _407_/S VPWR VGND sg13g2_mux2_1
X_337_ _502_/D _501_/Q _502_/Q _415_/S VPWR VGND sg13g2_mux2_1
X_268_ _640_/D _606_/Q _620_/Q _270_/S VPWR VGND sg13g2_mux2_1
XFILLER_6_551 VPWR VGND sg13g2_decap_8
XFILLER_21_801 VPWR VGND sg13g2_decap_8
XFILLER_12_812 VPWR VGND sg13g2_decap_8
XFILLER_12_889 VPWR VGND sg13g2_decap_8
XFILLER_8_805 VPWR VGND sg13g2_decap_8
XFILLER_3_521 VPWR VGND sg13g2_decap_8
XFILLER_3_598 VPWR VGND sg13g2_decap_8
XFILLER_46_285 VPWR VGND sg13g2_decap_8
XFILLER_47_786 VPWR VGND sg13g2_decap_8
Xinput10 _236_/A0 uio_in[0] VPWR VGND sg13g2_buf_1
XFILLER_10_1028 VPWR VGND sg13g2_fill_1
XFILLER_0_568 VPWR VGND sg13g2_decap_8
XFILLER_44_712 VPWR VGND sg13g2_decap_8
XFILLER_44_789 VPWR VGND sg13g2_decap_8
XFILLER_4_852 VPWR VGND sg13g2_decap_8
XFILLER_47_583 VPWR VGND sg13g2_decap_8
XFILLER_35_756 VPWR VGND sg13g2_decap_8
XFILLER_26_756 VPWR VGND sg13g2_decap_8
XFILLER_41_715 VPWR VGND sg13g2_decap_8
XFILLER_1_811 VPWR VGND sg13g2_decap_8
XFILLER_0_354 VPWR VGND sg13g2_decap_8
XFILLER_1_888 VPWR VGND sg13g2_decap_8
X_654_ _654_/Q _656_/CLK _654_/D fanout75/X VPWR VGND sg13g2_dfrbpq_1
XFILLER_49_826 VPWR VGND sg13g2_decap_8
XFILLER_48_369 VPWR VGND sg13g2_decap_8
XFILLER_17_756 VPWR VGND sg13g2_decap_8
XFILLER_44_586 VPWR VGND sg13g2_decap_8
X_585_ _612_/D _626_/CLK _585_/D fanout65/X VPWR VGND sg13g2_dfrbpq_1
XFILLER_13_984 VPWR VGND sg13g2_decap_8
XFILLER_40_781 VPWR VGND sg13g2_decap_8
XFILLER_9_955 VPWR VGND sg13g2_decap_8
XFILLER_47_380 VPWR VGND sg13g2_decap_8
XFILLER_31_770 VPWR VGND sg13g2_decap_8
X_370_ _535_/D _534_/Q _535_/Q _412_/S VPWR VGND sg13g2_mux2_1
XFILLER_10_921 VPWR VGND sg13g2_decap_8
XFILLER_10_998 VPWR VGND sg13g2_decap_8
XFILLER_22_792 VPWR VGND sg13g2_decap_8
XFILLER_6_936 VPWR VGND sg13g2_decap_8
XFILLER_1_685 VPWR VGND sg13g2_decap_8
XFILLER_49_623 VPWR VGND sg13g2_decap_8
XFILLER_45_851 VPWR VGND sg13g2_fill_1
X_637_ _637_/Q _451_/Y _637_/D fanout66/X VPWR VGND sg13g2_dfrbpq_1
XFILLER_13_781 VPWR VGND sg13g2_decap_8
XFILLER_44_361 VPWR VGND sg13g2_decap_8
X_568_ _568_/Q _570_/CLK _568_/D fanout94/X VPWR VGND sg13g2_dfrbpq_1
X_499_ _499_/Q _514_/CLK _499_/D fanout87/X VPWR VGND sg13g2_dfrbpq_1
XFILLER_9_752 VPWR VGND sg13g2_decap_8
XFILLER_28_818 VPWR VGND sg13g2_decap_8
XFILLER_3_906 VPWR VGND sg13g2_decap_8
XFILLER_46_615 VPWR VGND sg13g2_decap_8
X_422_ _587_/D _586_/Q _587_/Q _436_/S VPWR VGND sg13g2_mux2_1
X_353_ _518_/D _517_/Q _518_/Q _366_/S VPWR VGND sg13g2_mux2_1
X_284_ _284_/Y _284_/A1 _279_/Y _281_/Y _284_/B2 VPWR VGND sg13g2_a22oi_1
XFILLER_10_795 VPWR VGND sg13g2_decap_8
XFILLER_6_733 VPWR VGND sg13g2_decap_8
XFILLER_1_482 VPWR VGND sg13g2_decap_8
Xinput8 _617_/D ui_in[6] VPWR VGND sg13g2_buf_1
XFILLER_7_1010 VPWR VGND sg13g2_decap_8
XFILLER_49_420 VPWR VGND sg13g2_decap_8
XFILLER_18_840 VPWR VGND sg13g2_decap_8
XFILLER_18_851 VPWR VGND sg13g2_fill_1
XFILLER_45_681 VPWR VGND sg13g2_decap_8
XFILLER_49_497 VPWR VGND sg13g2_decap_8
XFILLER_13_1026 VPWR VGND sg13g2_fill_2
XFILLER_3_703 VPWR VGND sg13g2_decap_8
XFILLER_15_854 VPWR VGND sg13g2_decap_8
XFILLER_47_979 VPWR VGND sg13g2_fill_2
XFILLER_47_968 VPWR VGND sg13g2_fill_1
XFILLER_47_957 VPWR VGND sg13g2_decap_8
XFILLER_46_467 VPWR VGND sg13g2_decap_8
XFILLER_30_846 VPWR VGND sg13g2_decap_4
X_405_ _570_/D _569_/Q _570_/Q _405_/S VPWR VGND sg13g2_mux2_1
X_336_ _501_/D _500_/Q _501_/Q _349_/S VPWR VGND sg13g2_mux2_1
X_267_ _639_/D _605_/Q _619_/Q _270_/S VPWR VGND sg13g2_mux2_1
XFILLER_6_530 VPWR VGND sg13g2_decap_8
XFILLER_49_294 VPWR VGND sg13g2_decap_8
XFILLER_49_261 VPWR VGND sg13g2_fill_1
XFILLER_43_426 VPWR VGND sg13g2_fill_2
XFILLER_12_868 VPWR VGND sg13g2_decap_8
XFILLER_3_500 VPWR VGND sg13g2_decap_8
XFILLER_3_577 VPWR VGND sg13g2_decap_8
XFILLER_4_1013 VPWR VGND sg13g2_decap_8
XFILLER_47_765 VPWR VGND sg13g2_decap_8
XFILLER_46_264 VPWR VGND sg13g2_decap_8
Xinput11 _235_/A0 uio_in[1] VPWR VGND sg13g2_buf_1
X_319_ _484_/D _483_/Q _484_/Q _392_/S VPWR VGND sg13g2_mux2_1
XFILLER_6_360 VPWR VGND sg13g2_decap_8
Xclkbuf_1_0__f_clk delaybuf_10_clk/A clkbuf_0_clk/X VPWR VGND sg13g2_buf_16
XFILLER_38_798 VPWR VGND sg13g2_decap_8
XFILLER_0_547 VPWR VGND sg13g2_decap_8
XFILLER_17_927 VPWR VGND sg13g2_decap_8
XFILLER_29_798 VPWR VGND sg13g2_decap_8
XFILLER_44_768 VPWR VGND sg13g2_decap_8
XFILLER_4_831 VPWR VGND sg13g2_decap_8
XFILLER_47_562 VPWR VGND sg13g2_decap_8
XFILLER_5_639 VPWR VGND sg13g2_decap_8
XFILLER_1_867 VPWR VGND sg13g2_decap_8
XFILLER_49_805 VPWR VGND sg13g2_decap_8
XFILLER_49_1025 VPWR VGND sg13g2_decap_4
X_653_ _653_/Q _660_/CLK _653_/D fanout77/X VPWR VGND sg13g2_dfrbpq_1
XFILLER_48_348 VPWR VGND sg13g2_decap_8
XFILLER_13_963 VPWR VGND sg13g2_decap_8
XFILLER_32_749 VPWR VGND sg13g2_decap_8
XFILLER_44_565 VPWR VGND sg13g2_decap_8
X_584_ _584_/Q _626_/CLK _584_/D fanout65/X VPWR VGND sg13g2_dfrbpq_1
XFILLER_9_934 VPWR VGND sg13g2_decap_8
XFILLER_23_749 VPWR VGND sg13g2_decap_8
XFILLER_1_119 VPWR VGND sg13g2_fill_2
Xdelaybuf_27_clk delaybuf_28_clk/A delaybuf_27_clk/A VPWR VGND sg13g2_buf_16
XFILLER_45_307 VPWR VGND sg13g2_fill_1
XFILLER_45_318 VPWR VGND sg13g2_decap_8
XFILLER_10_900 VPWR VGND sg13g2_decap_8
XFILLER_14_749 VPWR VGND sg13g2_decap_8
XFILLER_16_1013 VPWR VGND sg13g2_decap_8
XFILLER_41_568 VPWR VGND sg13g2_decap_8
XFILLER_10_977 VPWR VGND sg13g2_decap_8
Xdelaybuf_18_clk delaybuf_19_clk/A delaybuf_18_clk/A VPWR VGND sg13g2_buf_16
XFILLER_6_915 VPWR VGND sg13g2_decap_8
XFILLER_1_664 VPWR VGND sg13g2_decap_8
XFILLER_49_602 VPWR VGND sg13g2_decap_8
XFILLER_44_340 VPWR VGND sg13g2_decap_8
X_567_ _567_/Q _567_/CLK _567_/D fanout94/X VPWR VGND sg13g2_dfrbpq_1
X_636_ _636_/Q _450_/Y _636_/D fanout66/X VPWR VGND sg13g2_dfrbpq_1
XFILLER_49_679 VPWR VGND sg13g2_decap_8
X_498_ _498_/Q _514_/CLK _498_/D fanout87/X VPWR VGND sg13g2_dfrbpq_1
XFILLER_10_0 VPWR VGND sg13g2_fill_2
XFILLER_19_819 VPWR VGND sg13g2_decap_4
X_421_ _586_/D _612_/D _586_/Q _436_/S VPWR VGND sg13g2_mux2_1
XFILLER_42_844 VPWR VGND sg13g2_decap_8
X_352_ _517_/D _516_/Q _517_/Q _366_/S VPWR VGND sg13g2_mux2_1
X_283_ _283_/Y _223_/Y _258_/A _282_/Y VPWR VGND sg13g2_o21ai_1
XFILLER_6_712 VPWR VGND sg13g2_decap_8
XFILLER_10_774 VPWR VGND sg13g2_decap_8
XFILLER_6_789 VPWR VGND sg13g2_decap_8
XFILLER_5_200 VPWR VGND sg13g2_decap_8
XFILLER_1_461 VPWR VGND sg13g2_decap_8
XFILLER_2_984 VPWR VGND sg13g2_decap_8
Xinput9 _618_/D ui_in[7] VPWR VGND sg13g2_buf_1
XFILLER_49_476 VPWR VGND sg13g2_decap_8
XFILLER_45_660 VPWR VGND sg13g2_decap_8
X_619_ _619_/Q _619_/CLK _619_/D fanout72/X VPWR VGND sg13g2_dfrbpq_1
XFILLER_13_1005 VPWR VGND sg13g2_decap_8
XFILLER_24_833 VPWR VGND sg13g2_decap_8
XFILLER_3_759 VPWR VGND sg13g2_decap_8
XFILLER_15_833 VPWR VGND sg13g2_decap_8
XFILLER_42_641 VPWR VGND sg13g2_decap_8
X_404_ _569_/D _568_/Q _569_/Q _405_/S VPWR VGND sg13g2_mux2_1
XFILLER_46_446 VPWR VGND sg13g2_decap_8
X_335_ _500_/D _499_/Q _500_/Q _349_/S VPWR VGND sg13g2_mux2_1
X_266_ _643_/D _266_/A _266_/B VPWR VGND sg13g2_nand2_1
XFILLER_2_781 VPWR VGND sg13g2_decap_8
XFILLER_6_586 VPWR VGND sg13g2_decap_8
XFILLER_0_729 VPWR VGND sg13g2_decap_8
XFILLER_43_405 VPWR VGND sg13g2_decap_8
XFILLER_12_847 VPWR VGND sg13g2_decap_8
XFILLER_7_339 VPWR VGND sg13g2_decap_8
XFILLER_3_556 VPWR VGND sg13g2_decap_8
XFILLER_47_744 VPWR VGND sg13g2_decap_8
Xinput12 _234_/A0 uio_in[2] VPWR VGND sg13g2_buf_1
X_318_ _483_/D _482_/Q _483_/Q _392_/S VPWR VGND sg13g2_mux2_1
X_249_ _249_/X _642_/Q _252_/B VPWR VGND sg13g2_and2_1
XFILLER_7_884 VPWR VGND sg13g2_decap_8
XFILLER_6_383 VPWR VGND sg13g2_fill_2
XFILLER_38_777 VPWR VGND sg13g2_decap_8
XFILLER_0_526 VPWR VGND sg13g2_decap_8
XFILLER_10_1019 VPWR VGND sg13g2_decap_8
XFILLER_29_777 VPWR VGND sg13g2_decap_8
XFILLER_44_747 VPWR VGND sg13g2_decap_8
XFILLER_3_320 VPWR VGND sg13g2_decap_8
XFILLER_7_114 VPWR VGND sg13g2_fill_1
XFILLER_4_810 VPWR VGND sg13g2_decap_8
XFILLER_4_887 VPWR VGND sg13g2_decap_8
XFILLER_47_541 VPWR VGND sg13g2_decap_8
Xclkbuf_leaf_6_clk _449_/B delaybuf_16_clk/X VPWR VGND sg13g2_buf_8
XFILLER_7_681 VPWR VGND sg13g2_decap_8
XFILLER_34_791 VPWR VGND sg13g2_decap_8
XFILLER_5_618 VPWR VGND sg13g2_decap_8
XFILLER_49_1004 VPWR VGND sg13g2_decap_8
XFILLER_0_389 VPWR VGND sg13g2_decap_4
XFILLER_1_846 VPWR VGND sg13g2_decap_8
XFILLER_1_1028 VPWR VGND sg13g2_fill_1
X_583_ _610_/D _616_/CLK _583_/D fanout66/X VPWR VGND sg13g2_dfrbpq_1
X_652_ _652_/Q _652_/CLK _652_/D fanout78/X VPWR VGND sg13g2_dfrbpq_1
XFILLER_48_327 VPWR VGND sg13g2_decap_8
XFILLER_13_942 VPWR VGND sg13g2_decap_8
XFILLER_25_791 VPWR VGND sg13g2_decap_8
XFILLER_9_913 VPWR VGND sg13g2_decap_8
XFILLER_4_684 VPWR VGND sg13g2_decap_8
XFILLER_0_890 VPWR VGND sg13g2_decap_8
XFILLER_16_791 VPWR VGND sg13g2_decap_8
XFILLER_48_894 VPWR VGND sg13g2_decap_8
XFILLER_46_809 VPWR VGND sg13g2_decap_8
Xclkbuf_0__017_ clkbuf_0__017_/X _256_/Y VPWR VGND sg13g2_buf_16
XFILLER_10_956 VPWR VGND sg13g2_decap_8
XFILLER_5_437 VPWR VGND sg13g2_decap_8
XFILLER_0_142 VPWR VGND sg13g2_fill_2
XFILLER_1_643 VPWR VGND sg13g2_decap_8
XFILLER_49_658 VPWR VGND sg13g2_decap_8
XFILLER_44_396 VPWR VGND sg13g2_decap_8
XFILLER_45_842 VPWR VGND sg13g2_decap_8
X_566_ _566_/Q _567_/CLK _566_/D fanout94/X VPWR VGND sg13g2_dfrbpq_1
X_635_ _635_/Q _449_/Y _635_/D fanout64/X VPWR VGND sg13g2_dfrbpq_1
X_497_ _497_/Q _515_/CLK _497_/D fanout87/X VPWR VGND sg13g2_dfrbpq_1
XFILLER_9_787 VPWR VGND sg13g2_decap_8
XFILLER_5_982 VPWR VGND sg13g2_decap_8
XFILLER_36_820 VPWR VGND sg13g2_decap_8
XFILLER_36_831 VPWR VGND sg13g2_fill_2
XFILLER_48_691 VPWR VGND sg13g2_decap_8
XFILLER_2_407 VPWR VGND sg13g2_fill_1
XFILLER_49_15 VPWR VGND sg13g2_fill_1
XFILLER_42_823 VPWR VGND sg13g2_decap_8
X_420_ _585_/D _584_/Q _612_/D _436_/S VPWR VGND sg13g2_mux2_1
X_351_ _516_/D _515_/Q _516_/Q _366_/S VPWR VGND sg13g2_mux2_1
X_282_ _282_/Y _282_/A1 _279_/Y _281_/Y _282_/B2 VPWR VGND sg13g2_a22oi_1
XFILLER_1_440 VPWR VGND sg13g2_decap_8
XFILLER_2_963 VPWR VGND sg13g2_decap_8
XFILLER_6_768 VPWR VGND sg13g2_decap_8
XFILLER_49_455 VPWR VGND sg13g2_decap_8
XFILLER_33_834 VPWR VGND sg13g2_decap_8
X_549_ _549_/Q _562_/CLK _549_/D fanout92/X VPWR VGND sg13g2_dfrbpq_1
X_618_ _618_/Q _649_/CLK _618_/D fanout76/X VPWR VGND sg13g2_dfrbpq_1
XFILLER_24_812 VPWR VGND sg13g2_decap_8
XFILLER_13_1028 VPWR VGND sg13g2_fill_1
XFILLER_3_738 VPWR VGND sg13g2_decap_8
XFILLER_47_915 VPWR VGND sg13g2_decap_4
XFILLER_46_425 VPWR VGND sg13g2_decap_8
XFILLER_15_812 VPWR VGND sg13g2_decap_8
XFILLER_15_889 VPWR VGND sg13g2_decap_8
XFILLER_30_826 VPWR VGND sg13g2_fill_2
XFILLER_42_620 VPWR VGND sg13g2_decap_8
X_403_ _568_/D _567_/Q _568_/Q _405_/S VPWR VGND sg13g2_mux2_1
X_334_ _499_/D _498_/Q _499_/Q _349_/S VPWR VGND sg13g2_mux2_1
X_265_ _644_/D _604_/Q _266_/A _264_/X VPWR VGND sg13g2_o21ai_1
XFILLER_6_565 VPWR VGND sg13g2_decap_8
XFILLER_2_760 VPWR VGND sg13g2_decap_8
XFILLER_21_815 VPWR VGND sg13g2_decap_8
XFILLER_0_708 VPWR VGND sg13g2_decap_8
XFILLER_12_826 VPWR VGND sg13g2_decap_8
XFILLER_8_819 VPWR VGND sg13g2_decap_8
XFILLER_7_318 VPWR VGND sg13g2_decap_8
XFILLER_3_535 VPWR VGND sg13g2_decap_8
XFILLER_46_299 VPWR VGND sg13g2_decap_8
XFILLER_47_723 VPWR VGND sg13g2_decap_8
Xinput13 _233_/A0 uio_in[3] VPWR VGND sg13g2_buf_1
X_317_ _482_/D _481_/Q _482_/Q _392_/S VPWR VGND sg13g2_mux2_1
X_248_ _248_/X _641_/Q _248_/B VPWR VGND sg13g2_and2_1
XFILLER_7_863 VPWR VGND sg13g2_decap_8
XFILLER_38_756 VPWR VGND sg13g2_decap_8
XFILLER_0_505 VPWR VGND sg13g2_decap_8
XFILLER_48_509 VPWR VGND sg13g2_decap_8
XFILLER_29_756 VPWR VGND sg13g2_decap_8
XFILLER_44_726 VPWR VGND sg13g2_decap_8
Xclkbuf_4_3_0_clk_regs clkbuf_4_3_0_clk_regs/X clkbuf_0_clk_regs/X VPWR VGND sg13g2_buf_8
XFILLER_3_310 VPWR VGND sg13g2_fill_2
XFILLER_7_137 VPWR VGND sg13g2_decap_8
XFILLER_4_866 VPWR VGND sg13g2_decap_8
XFILLER_47_597 VPWR VGND sg13g2_decap_8
XFILLER_7_660 VPWR VGND sg13g2_decap_8
XFILLER_34_770 VPWR VGND sg13g2_decap_8
XFILLER_41_729 VPWR VGND sg13g2_decap_8
XFILLER_0_302 VPWR VGND sg13g2_decap_8
XFILLER_0_368 VPWR VGND sg13g2_decap_4
XFILLER_1_825 VPWR VGND sg13g2_decap_8
XFILLER_48_306 VPWR VGND sg13g2_decap_8
XFILLER_1_1007 VPWR VGND sg13g2_decap_8
XFILLER_25_770 VPWR VGND sg13g2_decap_8
X_582_ _609_/D _623_/CLK _582_/D fanout71/X VPWR VGND sg13g2_dfrbpq_1
X_651_ _651_/Q _660_/CLK _651_/D fanout78/X VPWR VGND sg13g2_dfrbpq_1
XFILLER_13_921 VPWR VGND sg13g2_decap_8
XFILLER_13_998 VPWR VGND sg13g2_decap_8
XFILLER_40_795 VPWR VGND sg13g2_decap_8
XFILLER_9_969 VPWR VGND sg13g2_decap_8
XFILLER_4_663 VPWR VGND sg13g2_decap_8
XFILLER_48_873 VPWR VGND sg13g2_decap_8
XFILLER_16_770 VPWR VGND sg13g2_decap_8
XFILLER_47_394 VPWR VGND sg13g2_decap_8
XFILLER_31_784 VPWR VGND sg13g2_decap_8
XFILLER_8_980 VPWR VGND sg13g2_decap_8
XFILLER_39_840 VPWR VGND sg13g2_decap_8
XFILLER_39_851 VPWR VGND sg13g2_fill_1
XFILLER_10_935 VPWR VGND sg13g2_decap_8
XFILLER_1_622 VPWR VGND sg13g2_decap_8
XFILLER_1_699 VPWR VGND sg13g2_decap_8
XFILLER_45_821 VPWR VGND sg13g2_decap_8
X_634_ _634_/Q _448_/Y _634_/D fanout70/X VPWR VGND sg13g2_dfrbpq_1
XFILLER_49_637 VPWR VGND sg13g2_decap_8
XFILLER_44_375 VPWR VGND sg13g2_decap_8
X_565_ _565_/Q _567_/CLK _565_/D fanout94/X VPWR VGND sg13g2_dfrbpq_1
X_496_ _496_/Q _515_/CLK _496_/D fanout88/X VPWR VGND sg13g2_dfrbpq_1
XFILLER_13_795 VPWR VGND sg13g2_decap_8
XFILLER_9_766 VPWR VGND sg13g2_decap_8
XFILLER_5_961 VPWR VGND sg13g2_decap_8
XFILLER_36_843 VPWR VGND sg13g2_decap_8
XFILLER_48_670 VPWR VGND sg13g2_decap_8
XFILLER_46_629 VPWR VGND sg13g2_decap_8
XFILLER_27_843 VPWR VGND sg13g2_decap_8
XFILLER_41_367 VPWR VGND sg13g2_fill_1
XFILLER_42_802 VPWR VGND sg13g2_decap_8
X_350_ _515_/D _514_/Q _515_/Q _350_/S VPWR VGND sg13g2_mux2_1
X_281_ _281_/Y _281_/A _279_/B VPWR VGND sg13g2_nor2b_1
XFILLER_6_747 VPWR VGND sg13g2_decap_8
XFILLER_5_246 VPWR VGND sg13g2_fill_2
XFILLER_2_942 VPWR VGND sg13g2_decap_8
XFILLER_7_1024 VPWR VGND sg13g2_decap_4
XFILLER_1_496 VPWR VGND sg13g2_decap_8
X_617_ _617_/Q _649_/CLK _617_/D fanout76/X VPWR VGND sg13g2_dfrbpq_1
XFILLER_49_434 VPWR VGND sg13g2_decap_8
XFILLER_45_695 VPWR VGND sg13g2_decap_8
X_548_ _548_/Q _561_/CLK _548_/D fanout92/X VPWR VGND sg13g2_dfrbpq_1
X_479_ _479_/Q _534_/CLK _479_/D fanout90/X VPWR VGND sg13g2_dfrbpq_1
XFILLER_2_227 VPWR VGND sg13g2_fill_2
XFILLER_3_717 VPWR VGND sg13g2_decap_8
XFILLER_46_404 VPWR VGND sg13g2_decap_8
XFILLER_15_868 VPWR VGND sg13g2_decap_4
XFILLER_30_805 VPWR VGND sg13g2_decap_8
X_402_ _567_/D _566_/Q _567_/Q _405_/S VPWR VGND sg13g2_mux2_1
X_333_ _498_/D _497_/Q _498_/Q _349_/S VPWR VGND sg13g2_mux2_1
X_264_ _264_/X _618_/Q _266_/B VPWR VGND sg13g2_or2_1
XFILLER_41_50 VPWR VGND sg13g2_fill_2
XFILLER_6_544 VPWR VGND sg13g2_decap_8
XFILLER_12_805 VPWR VGND sg13g2_decap_8
XFILLER_3_514 VPWR VGND sg13g2_decap_8
XFILLER_47_702 VPWR VGND sg13g2_decap_8
XFILLER_36_72 VPWR VGND sg13g2_fill_1
XFILLER_46_245 VPWR VGND sg13g2_decap_4
XFILLER_46_278 VPWR VGND sg13g2_decap_8
XFILLER_4_1027 VPWR VGND sg13g2_fill_2
XFILLER_47_779 VPWR VGND sg13g2_decap_8
XFILLER_11_882 VPWR VGND sg13g2_decap_8
X_316_ _481_/D _480_/Q _481_/Q _323_/S VPWR VGND sg13g2_mux2_1
X_247_ _247_/X _640_/Q _248_/B VPWR VGND sg13g2_and2_1
XFILLER_7_842 VPWR VGND sg13g2_decap_8
XFILLER_6_385 VPWR VGND sg13g2_fill_1
XFILLER_44_705 VPWR VGND sg13g2_decap_8
XFILLER_4_845 VPWR VGND sg13g2_decap_8
XFILLER_28_790 VPWR VGND sg13g2_decap_8
XFILLER_35_749 VPWR VGND sg13g2_decap_8
XFILLER_43_793 VPWR VGND sg13g2_decap_8
XFILLER_47_576 VPWR VGND sg13g2_decap_8
XFILLER_8_43 VPWR VGND sg13g2_fill_2
XFILLER_6_193 VPWR VGND sg13g2_decap_8
XFILLER_26_749 VPWR VGND sg13g2_decap_8
XFILLER_41_708 VPWR VGND sg13g2_decap_8
XFILLER_1_804 VPWR VGND sg13g2_decap_8
XFILLER_0_347 VPWR VGND sg13g2_decap_8
X_650_ _650_/Q _660_/CLK _650_/D fanout77/X VPWR VGND sg13g2_dfrbpq_1
XFILLER_49_819 VPWR VGND sg13g2_decap_8
XFILLER_13_900 VPWR VGND sg13g2_decap_8
XFILLER_17_749 VPWR VGND sg13g2_decap_8
XFILLER_44_579 VPWR VGND sg13g2_decap_8
X_581_ _608_/D _581_/CLK _581_/D fanout89/X VPWR VGND sg13g2_dfrbpq_1
XFILLER_13_977 VPWR VGND sg13g2_decap_8
XFILLER_40_774 VPWR VGND sg13g2_decap_8
XFILLER_9_948 VPWR VGND sg13g2_decap_8
XFILLER_4_642 VPWR VGND sg13g2_decap_8
XFILLER_48_852 VPWR VGND sg13g2_decap_8
XFILLER_47_373 VPWR VGND sg13g2_decap_8
XFILLER_31_763 VPWR VGND sg13g2_decap_8
XFILLER_10_914 VPWR VGND sg13g2_decap_8
XFILLER_16_1027 VPWR VGND sg13g2_fill_2
XFILLER_22_785 VPWR VGND sg13g2_decap_8
XFILLER_6_929 VPWR VGND sg13g2_decap_8
XFILLER_0_144 VPWR VGND sg13g2_fill_1
XFILLER_1_601 VPWR VGND sg13g2_decap_8
XFILLER_1_678 VPWR VGND sg13g2_decap_8
XFILLER_49_616 VPWR VGND sg13g2_decap_8
XFILLER_45_800 VPWR VGND sg13g2_decap_8
X_633_ _633_/Q _447_/Y _633_/D fanout70/X VPWR VGND sg13g2_dfrbpq_1
XFILLER_13_774 VPWR VGND sg13g2_decap_8
XFILLER_44_354 VPWR VGND sg13g2_decap_8
X_564_ _564_/Q _567_/CLK _564_/D fanout94/X VPWR VGND sg13g2_dfrbpq_1
X_495_ _495_/Q _515_/CLK _495_/D fanout88/X VPWR VGND sg13g2_dfrbpq_1
XFILLER_5_940 VPWR VGND sg13g2_decap_8
XFILLER_4_450 VPWR VGND sg13g2_fill_1
XFILLER_46_608 VPWR VGND sg13g2_decap_8
X_280_ _280_/X _280_/A0 _280_/A1 _460_/A _649_/Q _279_/B _281_/A VPWR VGND sg13g2_mux4_1
XFILLER_10_788 VPWR VGND sg13g2_decap_8
XFILLER_6_726 VPWR VGND sg13g2_decap_8
XFILLER_5_258 VPWR VGND sg13g2_fill_1
XFILLER_5_214 VPWR VGND sg13g2_fill_1
XFILLER_1_475 VPWR VGND sg13g2_decap_8
XFILLER_2_921 VPWR VGND sg13g2_decap_8
XFILLER_2_998 VPWR VGND sg13g2_decap_8
XFILLER_7_1003 VPWR VGND sg13g2_decap_8
XFILLER_49_413 VPWR VGND sg13g2_decap_8
XFILLER_45_674 VPWR VGND sg13g2_decap_8
X_547_ _547_/Q _561_/CLK _547_/D fanout92/X VPWR VGND sg13g2_dfrbpq_1
X_616_ _616_/Q _616_/CLK _616_/D fanout67/X VPWR VGND sg13g2_dfrbpq_1
X_478_ _478_/Q _534_/CLK _478_/D fanout90/X VPWR VGND sg13g2_dfrbpq_1
XFILLER_24_847 VPWR VGND sg13g2_decap_4
XFILLER_13_1019 VPWR VGND sg13g2_decap_8
Xclkbuf_0_clk_regs clkbuf_0_clk_regs/X clkbuf_regs_0_clk/X VPWR VGND sg13g2_buf_16
X_401_ _566_/D _565_/Q _566_/Q _405_/S VPWR VGND sg13g2_mux2_1
XFILLER_15_847 VPWR VGND sg13g2_decap_8
XFILLER_30_828 VPWR VGND sg13g2_fill_1
XFILLER_30_839 VPWR VGND sg13g2_decap_8
X_332_ _497_/D _496_/Q _497_/Q _349_/S VPWR VGND sg13g2_mux2_1
X_263_ _645_/D _222_/Y _266_/A _262_/Y VPWR VGND sg13g2_o21ai_1
XFILLER_6_501 VPWR VGND sg13g2_fill_2
XFILLER_2_795 VPWR VGND sg13g2_decap_8
XFILLER_49_287 VPWR VGND sg13g2_decap_8
XFILLER_49_254 VPWR VGND sg13g2_decap_8
XFILLER_45_471 VPWR VGND sg13g2_decap_8
XFILLER_43_419 VPWR VGND sg13g2_decap_8
Xdelaybuf_1_clk u_delay_line/clk _440_/B VPWR VGND sg13g2_buf_16
XFILLER_4_1006 VPWR VGND sg13g2_decap_8
XFILLER_47_758 VPWR VGND sg13g2_decap_8
XFILLER_11_861 VPWR VGND sg13g2_decap_8
X_315_ _480_/D _479_/Q _480_/Q _323_/S VPWR VGND sg13g2_mux2_1
X_246_ _246_/X _639_/Q _248_/B VPWR VGND sg13g2_and2_1
XFILLER_7_821 VPWR VGND sg13g2_decap_8
XFILLER_6_353 VPWR VGND sg13g2_decap_8
XFILLER_2_592 VPWR VGND sg13g2_decap_8
XFILLER_7_898 VPWR VGND sg13g2_decap_8
XFILLER_45_290 VPWR VGND sg13g2_decap_8
XFILLER_4_824 VPWR VGND sg13g2_decap_8
XFILLER_47_555 VPWR VGND sg13g2_decap_8
XFILLER_43_772 VPWR VGND sg13g2_decap_8
X_229_ _467_/D _234_/A0 _655_/D _231_/S VPWR VGND sg13g2_mux2_1
XFILLER_7_695 VPWR VGND sg13g2_decap_8
XFILLER_6_172 VPWR VGND sg13g2_decap_8
XFILLER_19_791 VPWR VGND sg13g2_decap_8
XFILLER_49_1018 VPWR VGND sg13g2_decap_8
X_580_ _580_/Q _607_/CLK _580_/D fanout85/X VPWR VGND sg13g2_dfrbpq_1
XFILLER_13_956 VPWR VGND sg13g2_decap_8
XFILLER_44_525 VPWR VGND sg13g2_fill_1
XFILLER_44_558 VPWR VGND sg13g2_decap_8
XFILLER_9_927 VPWR VGND sg13g2_decap_8
XFILLER_4_621 VPWR VGND sg13g2_decap_8
XFILLER_4_698 VPWR VGND sg13g2_decap_8
XFILLER_48_831 VPWR VGND sg13g2_decap_8
XFILLER_47_352 VPWR VGND sg13g2_decap_8
XFILLER_7_481 VPWR VGND sg13g2_decap_4
XFILLER_16_1006 VPWR VGND sg13g2_decap_8
XFILLER_6_908 VPWR VGND sg13g2_decap_8
XFILLER_1_657 VPWR VGND sg13g2_decap_8
XFILLER_44_333 VPWR VGND sg13g2_decap_8
X_563_ _563_/Q _563_/CLK _563_/D fanout93/X VPWR VGND sg13g2_dfrbpq_1
X_632_ _632_/Q _446_/Y _632_/D fanout69/X VPWR VGND sg13g2_dfrbpq_1
X_494_ _494_/Q _563_/CLK _494_/D fanout96/X VPWR VGND sg13g2_dfrbpq_1
XFILLER_5_996 VPWR VGND sg13g2_decap_8
XFILLER_5_89 VPWR VGND sg13g2_fill_2
XFILLER_5_56 VPWR VGND sg13g2_fill_2
XFILLER_4_495 VPWR VGND sg13g2_decap_8
XFILLER_27_812 VPWR VGND sg13g2_decap_8
XFILLER_41_325 VPWR VGND sg13g2_fill_1
XFILLER_42_837 VPWR VGND sg13g2_decap_8
XFILLER_2_900 VPWR VGND sg13g2_decap_8
XFILLER_6_705 VPWR VGND sg13g2_decap_8
XFILLER_18_812 VPWR VGND sg13g2_decap_8
XFILLER_1_454 VPWR VGND sg13g2_decap_8
XFILLER_2_977 VPWR VGND sg13g2_decap_8
XFILLER_49_469 VPWR VGND sg13g2_decap_8
XFILLER_33_804 VPWR VGND sg13g2_fill_2
XFILLER_33_848 VPWR VGND sg13g2_decap_4
XFILLER_45_653 VPWR VGND sg13g2_decap_8
X_546_ _546_/Q _562_/CLK _546_/D fanout92/X VPWR VGND sg13g2_dfrbpq_1
X_615_ _615_/Q _623_/CLK _615_/D fanout66/X VPWR VGND sg13g2_dfrbpq_1
Xu_multimode_dll VPWR VGND _514_/Q _280_/A0 _496_/Q _497_/Q _498_/Q _499_/Q _500_/Q
+ _282_/A1 _501_/Q _502_/Q _503_/Q _504_/Q _505_/Q _284_/A1 _506_/Q _507_/Q _508_/Q
+ _509_/Q _510_/Q _515_/Q _603_/D _516_/Q _526_/Q _527_/Q _528_/Q _529_/Q _530_/Q
+ _531_/Q _532_/Q _533_/Q _534_/Q _535_/Q _517_/Q _536_/Q _537_/Q _538_/Q _539_/Q
+ _540_/Q _541_/Q _518_/Q _519_/Q _520_/Q _521_/Q _522_/Q _523_/Q _524_/Q _525_/Q
+ _481_/Q _482_/Q _483_/Q _484_/Q _485_/Q _486_/Q _487_/Q _488_/Q _489_/Q _490_/Q
+ _491_/Q _492_/Q _493_/Q _494_/Q _495_/Q _476_/Q _477_/Q _478_/Q _479_/Q _480_/Q
+ _511_/Q _512_/Q _513_/Q delaybuf_0_clk/X _286_/A1 fanout88/X _288_/A1 multimode_dll
X_477_ _477_/Q _534_/CLK _477_/D fanout90/X VPWR VGND sg13g2_dfrbpq_1
XFILLER_5_793 VPWR VGND sg13g2_decap_8
XFILLER_24_826 VPWR VGND sg13g2_decap_8
XFILLER_15_826 VPWR VGND sg13g2_decap_8
XFILLER_42_634 VPWR VGND sg13g2_decap_8
X_400_ _565_/D _564_/Q _565_/Q _405_/S VPWR VGND sg13g2_mux2_1
X_331_ _496_/D _495_/Q _496_/Q _350_/S VPWR VGND sg13g2_mux2_1
XFILLER_46_439 VPWR VGND sg13g2_decap_8
X_262_ _262_/Y _270_/S _617_/Q _618_/Q VPWR VGND sg13g2_nand3_1
XFILLER_2_774 VPWR VGND sg13g2_decap_8
XFILLER_6_579 VPWR VGND sg13g2_decap_8
XFILLER_21_829 VPWR VGND sg13g2_decap_4
XFILLER_45_450 VPWR VGND sg13g2_decap_8
X_529_ _529_/Q _541_/CLK _529_/D fanout70/X VPWR VGND sg13g2_dfrbpq_1
XFILLER_5_590 VPWR VGND sg13g2_decap_8
XFILLER_20_851 VPWR VGND sg13g2_fill_1
XFILLER_3_549 VPWR VGND sg13g2_decap_8
XFILLER_47_737 VPWR VGND sg13g2_decap_8
XFILLER_42_431 VPWR VGND sg13g2_decap_4
X_314_ _479_/D _478_/Q _479_/Q _323_/S VPWR VGND sg13g2_mux2_1
XFILLER_11_840 VPWR VGND sg13g2_decap_8
X_245_ _245_/X _638_/Q _248_/B VPWR VGND sg13g2_and2_1
XFILLER_7_877 VPWR VGND sg13g2_decap_8
XFILLER_7_800 VPWR VGND sg13g2_decap_8
XFILLER_2_571 VPWR VGND sg13g2_decap_8
XFILLER_46_781 VPWR VGND sg13g2_decap_8
XFILLER_0_519 VPWR VGND sg13g2_decap_8
XFILLER_37_770 VPWR VGND sg13g2_decap_8
XFILLER_7_129 VPWR VGND sg13g2_decap_4
XFILLER_4_803 VPWR VGND sg13g2_decap_8
XFILLER_3_368 VPWR VGND sg13g2_decap_8
XFILLER_16_910 VPWR VGND sg13g2_decap_8
XFILLER_43_751 VPWR VGND sg13g2_decap_8
XFILLER_8_45 VPWR VGND sg13g2_fill_1
X_228_ _468_/D _233_/A0 _656_/D _231_/S VPWR VGND sg13g2_mux2_1
XFILLER_7_674 VPWR VGND sg13g2_decap_8
XFILLER_19_770 VPWR VGND sg13g2_decap_8
XFILLER_34_784 VPWR VGND sg13g2_decap_8
XFILLER_1_839 VPWR VGND sg13g2_decap_8
XFILLER_13_935 VPWR VGND sg13g2_decap_8
XFILLER_25_784 VPWR VGND sg13g2_decap_8
XFILLER_9_906 VPWR VGND sg13g2_decap_8
XFILLER_4_677 VPWR VGND sg13g2_decap_8
XFILLER_4_600 VPWR VGND sg13g2_decap_8
XFILLER_0_883 VPWR VGND sg13g2_decap_8
XFILLER_48_810 VPWR VGND sg13g2_decap_8
XFILLER_47_331 VPWR VGND sg13g2_decap_8
XFILLER_16_784 VPWR VGND sg13g2_decap_8
XFILLER_48_887 VPWR VGND sg13g2_decap_8
XFILLER_31_798 VPWR VGND sg13g2_decap_8
Xclkbuf_4_2_0_clk_regs clkbuf_4_2_0_clk_regs/X clkbuf_0_clk_regs/X VPWR VGND sg13g2_buf_8
XFILLER_7_460 VPWR VGND sg13g2_decap_8
XFILLER_8_994 VPWR VGND sg13g2_decap_8
XFILLER_22_754 VPWR VGND sg13g2_decap_4
XFILLER_10_949 VPWR VGND sg13g2_decap_8
XFILLER_0_179 VPWR VGND sg13g2_decap_4
XFILLER_1_636 VPWR VGND sg13g2_decap_8
XFILLER_44_389 VPWR VGND sg13g2_decap_8
XFILLER_45_835 VPWR VGND sg13g2_decap_8
X_562_ _562_/Q _562_/CLK _562_/D fanout92/X VPWR VGND sg13g2_dfrbpq_1
X_631_ _631_/Q _445_/Y _631_/D fanout71/X VPWR VGND sg13g2_dfrbpq_1
X_493_ _493_/Q _563_/CLK _493_/D fanout88/X VPWR VGND sg13g2_dfrbpq_1
XFILLER_5_975 VPWR VGND sg13g2_decap_8
XFILLER_5_68 VPWR VGND sg13g2_fill_1
XFILLER_0_680 VPWR VGND sg13g2_decap_8
XFILLER_36_813 VPWR VGND sg13g2_decap_8
XFILLER_48_684 VPWR VGND sg13g2_decap_8
XFILLER_8_791 VPWR VGND sg13g2_decap_8
XFILLER_42_816 VPWR VGND sg13g2_decap_8
XFILLER_1_433 VPWR VGND sg13g2_decap_8
XFILLER_2_956 VPWR VGND sg13g2_decap_8
XFILLER_49_448 VPWR VGND sg13g2_decap_8
XFILLER_45_632 VPWR VGND sg13g2_decap_8
X_545_ _545_/Q _557_/CLK _545_/D fanout95/X VPWR VGND sg13g2_dfrbpq_1
X_614_ _614_/Q _627_/CLK _614_/D fanout65/X VPWR VGND sg13g2_dfrbpq_1
X_476_ _476_/Q _659_/CLK _476_/D fanout80/X VPWR VGND sg13g2_dfrbpq_1
Xdelaybuf_20_clk delaybuf_21_clk/A delaybuf_20_clk/A VPWR VGND sg13g2_buf_16
XFILLER_5_772 VPWR VGND sg13g2_decap_8
XFILLER_24_805 VPWR VGND sg13g2_decap_8
XFILLER_48_481 VPWR VGND sg13g2_decap_8
Xdelaybuf_11_clk delaybuf_12_clk/A delaybuf_11_clk/A VPWR VGND sg13g2_buf_16
XFILLER_47_919 VPWR VGND sg13g2_fill_1
XFILLER_47_908 VPWR VGND sg13g2_decap_8
XFILLER_46_418 VPWR VGND sg13g2_decap_8
XFILLER_15_805 VPWR VGND sg13g2_decap_8
XFILLER_30_819 VPWR VGND sg13g2_decap_8
XFILLER_41_112 VPWR VGND sg13g2_fill_1
XFILLER_42_613 VPWR VGND sg13g2_decap_8
X_330_ _495_/D _494_/Q _495_/Q _350_/S VPWR VGND sg13g2_mux2_1
X_261_ _266_/B _270_/S _617_/Q VPWR VGND sg13g2_nand2_1
XFILLER_6_558 VPWR VGND sg13g2_decap_8
XFILLER_2_753 VPWR VGND sg13g2_decap_8
XFILLER_14_882 VPWR VGND sg13g2_decap_8
XFILLER_21_808 VPWR VGND sg13g2_decap_8
X_528_ _528_/Q _541_/CLK _528_/D fanout70/X VPWR VGND sg13g2_dfrbpq_1
X_459_ _459_/Y _459_/A _459_/B VPWR VGND sg13g2_xnor2_1
XFILLER_12_819 VPWR VGND sg13g2_decap_8
XFILLER_20_830 VPWR VGND sg13g2_decap_8
XFILLER_3_528 VPWR VGND sg13g2_decap_8
Xclkbuf_4_15_0_clk_regs clkbuf_4_15_0_clk_regs/X clkbuf_0_clk_regs/X VPWR VGND sg13g2_buf_8
XFILLER_47_716 VPWR VGND sg13g2_decap_8
X_313_ _478_/D _477_/Q _478_/Q _323_/S VPWR VGND sg13g2_mux2_1
X_244_ _244_/X _637_/Q _248_/B VPWR VGND sg13g2_and2_1
XFILLER_11_896 VPWR VGND sg13g2_decap_8
XFILLER_7_856 VPWR VGND sg13g2_decap_8
XFILLER_2_550 VPWR VGND sg13g2_decap_8
XFILLER_38_749 VPWR VGND sg13g2_decap_8
XFILLER_46_760 VPWR VGND sg13g2_decap_8
XFILLER_29_749 VPWR VGND sg13g2_decap_8
XFILLER_44_719 VPWR VGND sg13g2_decap_8
XFILLER_4_859 VPWR VGND sg13g2_decap_8
XFILLER_0_4 VPWR VGND sg13g2_fill_1
XFILLER_43_730 VPWR VGND sg13g2_decap_8
X_227_ _231_/S _648_/Q _647_/Q VPWR VGND sg13g2_nand2_1
XFILLER_3_892 VPWR VGND sg13g2_decap_8
XFILLER_7_653 VPWR VGND sg13g2_decap_8
XFILLER_34_763 VPWR VGND sg13g2_decap_8
XFILLER_1_818 VPWR VGND sg13g2_decap_8
XFILLER_13_914 VPWR VGND sg13g2_decap_8
XFILLER_25_763 VPWR VGND sg13g2_decap_8
XFILLER_33_32 VPWR VGND sg13g2_fill_1
XFILLER_40_788 VPWR VGND sg13g2_decap_8
XFILLER_3_144 VPWR VGND sg13g2_decap_8
XFILLER_4_656 VPWR VGND sg13g2_decap_8
XFILLER_0_862 VPWR VGND sg13g2_decap_8
XFILLER_48_866 VPWR VGND sg13g2_fill_2
XFILLER_47_310 VPWR VGND sg13g2_decap_8
XFILLER_16_763 VPWR VGND sg13g2_decap_8
XFILLER_43_582 VPWR VGND sg13g2_decap_8
XFILLER_47_387 VPWR VGND sg13g2_decap_8
XFILLER_12_980 VPWR VGND sg13g2_decap_8
XFILLER_31_777 VPWR VGND sg13g2_decap_8
XFILLER_8_973 VPWR VGND sg13g2_decap_8
XFILLER_24_0 VPWR VGND sg13g2_fill_1
XFILLER_48_1020 VPWR VGND sg13g2_decap_8
XFILLER_39_833 VPWR VGND sg13g2_decap_8
XFILLER_0_91 VPWR VGND sg13g2_fill_1
XFILLER_10_928 VPWR VGND sg13g2_decap_8
XFILLER_22_799 VPWR VGND sg13g2_decap_8
XFILLER_1_615 VPWR VGND sg13g2_decap_8
X_630_ _630_/Q _630_/CLK _630_/D fanout66/X VPWR VGND sg13g2_dfrbpq_1
Xclkbuf_1_1__f_clk clkload0/A delaybuf_22_clk/X VPWR VGND sg13g2_buf_16
XFILLER_44_368 VPWR VGND sg13g2_decap_8
XFILLER_45_814 VPWR VGND sg13g2_decap_8
X_561_ _561_/Q _561_/CLK _561_/D fanout92/X VPWR VGND sg13g2_dfrbpq_1
X_492_ _492_/Q _515_/CLK _492_/D fanout88/X VPWR VGND sg13g2_dfrbpq_1
XFILLER_13_788 VPWR VGND sg13g2_decap_8
XFILLER_9_759 VPWR VGND sg13g2_decap_8
XFILLER_5_954 VPWR VGND sg13g2_decap_8
XFILLER_48_663 VPWR VGND sg13g2_decap_8
XFILLER_47_162 VPWR VGND sg13g2_fill_1
XFILLER_8_770 VPWR VGND sg13g2_decap_8
XFILLER_7_280 VPWR VGND sg13g2_decap_8
XFILLER_27_836 VPWR VGND sg13g2_decap_8
XFILLER_2_935 VPWR VGND sg13g2_decap_8
XFILLER_7_1017 VPWR VGND sg13g2_decap_8
XFILLER_18_847 VPWR VGND sg13g2_decap_4
XFILLER_1_489 VPWR VGND sg13g2_decap_8
XFILLER_45_611 VPWR VGND sg13g2_decap_8
X_613_ _613_/Q _627_/CLK _613_/D fanout64/X VPWR VGND sg13g2_dfrbpq_1
XFILLER_7_1028 VPWR VGND sg13g2_fill_1
XFILLER_49_427 VPWR VGND sg13g2_decap_8
XFILLER_33_806 VPWR VGND sg13g2_fill_1
XFILLER_45_688 VPWR VGND sg13g2_decap_8
X_544_ _544_/Q _557_/CLK _544_/D fanout95/X VPWR VGND sg13g2_dfrbpq_1
X_475_ _475_/Q _652_/CLK _475_/D fanout80/X VPWR VGND sg13g2_dfrbpq_1
XFILLER_5_751 VPWR VGND sg13g2_decap_8
XFILLER_49_950 VPWR VGND sg13g2_decap_4
XFILLER_48_460 VPWR VGND sg13g2_decap_8
X_260_ _266_/A _647_/D _603_/Q VPWR VGND sg13g2_nand2_1
Xdelaybuf_4_clk delaybuf_5_clk/A delaybuf_4_clk/A VPWR VGND sg13g2_buf_16
XFILLER_6_537 VPWR VGND sg13g2_decap_8
XFILLER_2_732 VPWR VGND sg13g2_decap_8
XFILLER_45_485 VPWR VGND sg13g2_fill_2
X_527_ _527_/Q _656_/CLK _527_/D fanout70/X VPWR VGND sg13g2_dfrbpq_1
XFILLER_14_861 VPWR VGND sg13g2_decap_8
XFILLER_41_680 VPWR VGND sg13g2_decap_8
X_458_ _458_/Y _460_/A _460_/B VPWR VGND sg13g2_xnor2_1
X_389_ _554_/D _553_/Q _554_/Q _391_/S VPWR VGND sg13g2_mux2_1
XFILLER_12_1022 VPWR VGND sg13g2_decap_8
Xclkbuf_1_0__f__017__regs _257__99/A clkbuf_0__017__regs/X VPWR VGND sg13g2_buf_16
XFILLER_49_791 VPWR VGND sg13g2_decap_8
XFILLER_3_507 VPWR VGND sg13g2_decap_8
XFILLER_11_68 VPWR VGND sg13g2_fill_1
XFILLER_42_400 VPWR VGND sg13g2_decap_4
XFILLER_46_249 VPWR VGND sg13g2_fill_2
XFILLER_11_875 VPWR VGND sg13g2_decap_8
X_312_ _477_/D _476_/Q _477_/Q _323_/S VPWR VGND sg13g2_mux2_1
X_243_ _243_/X _636_/Q _248_/B VPWR VGND sg13g2_and2_1
XFILLER_7_835 VPWR VGND sg13g2_decap_8
XFILLER_6_367 VPWR VGND sg13g2_fill_2
XFILLER_4_838 VPWR VGND sg13g2_decap_8
XFILLER_16_967 VPWR VGND sg13g2_fill_2
XFILLER_28_783 VPWR VGND sg13g2_decap_8
XFILLER_43_786 VPWR VGND sg13g2_decap_8
XFILLER_47_569 VPWR VGND sg13g2_decap_8
X_226_ _226_/Y _653_/Q VPWR VGND sg13g2_inv_1
XFILLER_7_632 VPWR VGND sg13g2_decap_8
XFILLER_6_142 VPWR VGND sg13g2_decap_4
XFILLER_2_381 VPWR VGND sg13g2_decap_4
XFILLER_3_871 VPWR VGND sg13g2_decap_8
XFILLER_6_186 VPWR VGND sg13g2_decap_8
XFILLER_46_580 VPWR VGND sg13g2_decap_8
XFILLER_0_841 VPWR VGND sg13g2_decap_8
XFILLER_3_178 VPWR VGND sg13g2_fill_2
XFILLER_4_635 VPWR VGND sg13g2_decap_8
Xclkbuf_2_1__f_clk_delayed _444_/A clkbuf_0_clk_delayed/X VPWR VGND sg13g2_buf_16
XFILLER_48_845 VPWR VGND sg13g2_decap_8
XFILLER_47_366 VPWR VGND sg13g2_decap_8
XFILLER_31_756 VPWR VGND sg13g2_decap_8
XFILLER_43_561 VPWR VGND sg13g2_decap_8
XFILLER_8_952 VPWR VGND sg13g2_decap_8
XFILLER_7_495 VPWR VGND sg13g2_fill_2
XFILLER_39_812 VPWR VGND sg13g2_decap_8
XFILLER_0_1023 VPWR VGND sg13g2_decap_4
XFILLER_10_907 VPWR VGND sg13g2_decap_8
X_560_ _560_/Q _561_/CLK _560_/D fanout93/X VPWR VGND sg13g2_dfrbpq_1
XFILLER_49_609 VPWR VGND sg13g2_decap_8
XFILLER_44_347 VPWR VGND sg13g2_decap_8
X_491_ _491_/Q _515_/CLK _491_/D fanout88/X VPWR VGND sg13g2_dfrbpq_1
XFILLER_5_933 VPWR VGND sg13g2_decap_8
XFILLER_48_642 VPWR VGND sg13g2_decap_8
XFILLER_43_391 VPWR VGND sg13g2_decap_8
XFILLER_6_719 VPWR VGND sg13g2_decap_8
XFILLER_5_207 VPWR VGND sg13g2_decap_8
XFILLER_1_468 VPWR VGND sg13g2_decap_8
XFILLER_2_914 VPWR VGND sg13g2_decap_8
XFILLER_49_406 VPWR VGND sg13g2_decap_8
XFILLER_18_826 VPWR VGND sg13g2_decap_4
XFILLER_45_667 VPWR VGND sg13g2_decap_8
X_543_ _543_/Q _557_/CLK _543_/D fanout95/X VPWR VGND sg13g2_dfrbpq_1
X_612_ _612_/Q _612_/CLK _612_/D fanout69/X VPWR VGND sg13g2_dfrbpq_1
X_474_ _474_/Q _659_/CLK _474_/D fanout78/X VPWR VGND sg13g2_dfrbpq_1
XFILLER_5_730 VPWR VGND sg13g2_decap_8
XFILLER_23_851 VPWR VGND sg13g2_fill_1
XFILLER_41_147 VPWR VGND sg13g2_fill_1
XFILLER_42_648 VPWR VGND sg13g2_fill_2
XFILLER_2_711 VPWR VGND sg13g2_decap_8
XFILLER_2_788 VPWR VGND sg13g2_decap_8
XFILLER_14_840 VPWR VGND sg13g2_decap_8
XFILLER_45_464 VPWR VGND sg13g2_decap_8
X_526_ _526_/Q _656_/CLK _526_/D fanout69/X VPWR VGND sg13g2_dfrbpq_1
XFILLER_12_1001 VPWR VGND sg13g2_decap_8
X_457_ _457_/Y _460_/A _459_/B VPWR VGND sg13g2_xnor2_1
X_388_ _553_/D _552_/Q _553_/Q _391_/S VPWR VGND sg13g2_mux2_1
XFILLER_49_770 VPWR VGND sg13g2_decap_8
XFILLER_11_854 VPWR VGND sg13g2_decap_8
X_311_ _476_/D _476_/Q input3/X _311_/S VPWR VGND sg13g2_mux2_1
X_242_ _242_/X _635_/Q _248_/B VPWR VGND sg13g2_and2_1
XFILLER_7_814 VPWR VGND sg13g2_decap_8
XFILLER_2_585 VPWR VGND sg13g2_decap_8
XFILLER_45_283 VPWR VGND sg13g2_decap_8
X_509_ _509_/Q _579_/CLK _509_/D fanout84/X VPWR VGND sg13g2_dfrbpq_1
XFILLER_46_795 VPWR VGND sg13g2_decap_8
XFILLER_6_880 VPWR VGND sg13g2_decap_8
XFILLER_3_81 VPWR VGND sg13g2_fill_1
XFILLER_37_784 VPWR VGND sg13g2_decap_8
XFILLER_3_327 VPWR VGND sg13g2_decap_4
XFILLER_4_817 VPWR VGND sg13g2_decap_8
XFILLER_47_98 VPWR VGND sg13g2_fill_2
XFILLER_47_548 VPWR VGND sg13g2_decap_8
XFILLER_16_924 VPWR VGND sg13g2_decap_4
XFILLER_28_762 VPWR VGND sg13g2_decap_8
XFILLER_43_765 VPWR VGND sg13g2_decap_8
XFILLER_8_15 VPWR VGND sg13g2_fill_1
X_225_ _225_/Y _652_/Q VPWR VGND sg13g2_inv_1
XFILLER_7_688 VPWR VGND sg13g2_decap_8
XFILLER_7_611 VPWR VGND sg13g2_decap_8
XFILLER_6_165 VPWR VGND sg13g2_decap_8
XFILLER_2_360 VPWR VGND sg13g2_decap_8
XFILLER_3_850 VPWR VGND sg13g2_decap_8
XFILLER_19_784 VPWR VGND sg13g2_decap_8
XFILLER_13_949 VPWR VGND sg13g2_decap_8
XFILLER_17_35 VPWR VGND sg13g2_fill_1
XFILLER_25_798 VPWR VGND sg13g2_decap_8
XFILLER_4_614 VPWR VGND sg13g2_decap_8
XFILLER_0_820 VPWR VGND sg13g2_decap_8
XFILLER_0_897 VPWR VGND sg13g2_decap_8
XFILLER_48_868 VPWR VGND sg13g2_fill_1
XFILLER_48_824 VPWR VGND sg13g2_decap_8
XFILLER_47_345 VPWR VGND sg13g2_decap_8
XFILLER_16_798 VPWR VGND sg13g2_decap_8
XFILLER_8_931 VPWR VGND sg13g2_decap_8
XFILLER_7_474 VPWR VGND sg13g2_decap_8
XFILLER_0_1002 VPWR VGND sg13g2_decap_8
XFILLER_44_326 VPWR VGND sg13g2_decap_8
XFILLER_45_849 VPWR VGND sg13g2_fill_2
X_490_ _490_/Q _514_/CLK _490_/D fanout87/X VPWR VGND sg13g2_dfrbpq_1
XFILLER_5_989 VPWR VGND sg13g2_decap_8
XFILLER_5_912 VPWR VGND sg13g2_decap_8
XFILLER_0_694 VPWR VGND sg13g2_decap_8
XFILLER_4_488 VPWR VGND sg13g2_decap_8
XFILLER_48_621 VPWR VGND sg13g2_decap_8
XFILLER_36_827 VPWR VGND sg13g2_decap_4
XFILLER_43_370 VPWR VGND sg13g2_decap_8
XFILLER_48_698 VPWR VGND sg13g2_decap_8
Xdelaybuf_23_clk delaybuf_24_clk/A clk VPWR VGND sg13g2_buf_16
XFILLER_7_271 VPWR VGND sg13g2_fill_1
XFILLER_27_805 VPWR VGND sg13g2_decap_8
XFILLER_1_447 VPWR VGND sg13g2_decap_8
Xclkbuf_4_1_0_clk_regs clkbuf_4_1_0_clk_regs/X clkbuf_0_clk_regs/X VPWR VGND sg13g2_buf_8
Xdelaybuf_14_clk delaybuf_15_clk/A delaybuf_14_clk/A VPWR VGND sg13g2_buf_16
XFILLER_18_805 VPWR VGND sg13g2_decap_8
XFILLER_45_646 VPWR VGND sg13g2_decap_8
X_542_ _542_/Q _563_/CLK _542_/D fanout93/X VPWR VGND sg13g2_dfrbpq_1
X_611_ _611_/Q _612_/CLK _611_/D fanout68/X VPWR VGND sg13g2_dfrbpq_1
X_473_ _473_/Q _660_/CLK _473_/D fanout78/X VPWR VGND sg13g2_dfrbpq_1
XFILLER_41_841 VPWR VGND sg13g2_decap_8
XFILLER_5_786 VPWR VGND sg13g2_decap_8
XFILLER_0_491 VPWR VGND sg13g2_decap_8
XFILLER_48_495 VPWR VGND sg13g2_decap_8
XFILLER_24_819 VPWR VGND sg13g2_decap_8
XFILLER_15_819 VPWR VGND sg13g2_decap_8
XFILLER_42_627 VPWR VGND sg13g2_decap_8
XFILLER_23_830 VPWR VGND sg13g2_decap_8
XFILLER_2_767 VPWR VGND sg13g2_decap_8
XFILLER_45_443 VPWR VGND sg13g2_decap_8
X_525_ _525_/Q _612_/CLK _525_/D fanout69/X VPWR VGND sg13g2_dfrbpq_1
X_456_ _456_/Y _456_/A _456_/B VPWR VGND sg13g2_xnor2_1
XFILLER_14_896 VPWR VGND sg13g2_decap_8
X_387_ _552_/D _551_/Q _552_/Q _405_/S VPWR VGND sg13g2_mux2_1
XFILLER_5_583 VPWR VGND sg13g2_decap_8
XFILLER_48_292 VPWR VGND sg13g2_decap_8
XFILLER_20_844 VPWR VGND sg13g2_decap_8
XFILLER_42_435 VPWR VGND sg13g2_fill_1
X_310_ _475_/D _475_/Q _310_/B VPWR VGND sg13g2_xnor2_1
XFILLER_11_833 VPWR VGND sg13g2_decap_8
X_241_ _241_/X _656_/Q _254_/B VPWR VGND sg13g2_and2_1
XFILLER_2_564 VPWR VGND sg13g2_decap_8
XFILLER_45_262 VPWR VGND sg13g2_decap_8
XFILLER_46_774 VPWR VGND sg13g2_decap_8
X_508_ _508_/Q _579_/CLK _508_/D fanout72/X VPWR VGND sg13g2_dfrbpq_1
X_439_ _439_/Y _444_/A _440_/B VPWR VGND sg13g2_xnor2_1
XFILLER_3_1011 VPWR VGND sg13g2_decap_8
XFILLER_37_763 VPWR VGND sg13g2_decap_8
XFILLER_22_36 VPWR VGND sg13g2_fill_2
XFILLER_3_306 VPWR VGND sg13g2_decap_4
XFILLER_43_744 VPWR VGND sg13g2_decap_8
X_224_ _224_/Y _651_/Q VPWR VGND sg13g2_inv_1
XFILLER_7_667 VPWR VGND sg13g2_decap_8
XFILLER_19_763 VPWR VGND sg13g2_decap_8
XFILLER_34_777 VPWR VGND sg13g2_decap_8
Xclkbuf_4_14_0_clk_regs clkbuf_4_14_0_clk_regs/X clkbuf_0_clk_regs/X VPWR VGND sg13g2_buf_8
XFILLER_0_309 VPWR VGND sg13g2_fill_1
XFILLER_13_928 VPWR VGND sg13g2_decap_8
XFILLER_25_777 VPWR VGND sg13g2_decap_8
XFILLER_0_876 VPWR VGND sg13g2_decap_8
XFILLER_48_803 VPWR VGND sg13g2_decap_8
XFILLER_16_777 VPWR VGND sg13g2_decap_8
XFILLER_47_324 VPWR VGND sg13g2_decap_8
XFILLER_12_994 VPWR VGND sg13g2_decap_8
XFILLER_43_596 VPWR VGND sg13g2_decap_8
XFILLER_8_910 VPWR VGND sg13g2_decap_8
XFILLER_8_987 VPWR VGND sg13g2_decap_8
XFILLER_7_453 VPWR VGND sg13g2_decap_8
XFILLER_39_847 VPWR VGND sg13g2_decap_4
Xclkbuf_leaf_2_clk _444_/B delaybuf_16_clk/X VPWR VGND sg13g2_buf_8
XFILLER_46_390 VPWR VGND sg13g2_decap_8
XFILLER_47_891 VPWR VGND sg13g2_decap_8
XFILLER_30_791 VPWR VGND sg13g2_decap_8
XFILLER_1_629 VPWR VGND sg13g2_decap_8
XFILLER_45_828 VPWR VGND sg13g2_decap_8
XFILLER_21_780 VPWR VGND sg13g2_decap_8
XFILLER_5_968 VPWR VGND sg13g2_decap_8
XFILLER_0_673 VPWR VGND sg13g2_decap_8
XFILLER_48_677 VPWR VGND sg13g2_decap_8
XFILLER_48_600 VPWR VGND sg13g2_decap_8
XFILLER_12_791 VPWR VGND sg13g2_decap_8
XFILLER_8_784 VPWR VGND sg13g2_decap_8
XFILLER_7_294 VPWR VGND sg13g2_decap_8
XFILLER_42_809 VPWR VGND sg13g2_decap_8
Xu_custom_cells.u_final_mux.SwitchMatrixMultiplexer_inv_inst _577_/Q _284_/B2 VPWR
+ _288_/B2 _280_/A1 VGND _575_/Q SwitchMatrixMultiplexer_inv
XFILLER_1_426 VPWR VGND sg13g2_decap_8
XFILLER_2_949 VPWR VGND sg13g2_decap_8
X_610_ _610_/Q _628_/CLK _610_/D fanout65/X VPWR VGND sg13g2_dfrbpq_1
XFILLER_41_820 VPWR VGND sg13g2_decap_8
XFILLER_45_625 VPWR VGND sg13g2_decap_8
X_541_ _541_/Q _541_/CLK _541_/D fanout70/X VPWR VGND sg13g2_dfrbpq_1
X_472_ _472_/Q _652_/CLK _472_/D fanout80/X VPWR VGND sg13g2_dfrbpq_1
Xdelaybuf_7_clk delaybuf_8_clk/A delaybuf_7_clk/A VPWR VGND sg13g2_buf_16
XFILLER_5_765 VPWR VGND sg13g2_decap_8
XFILLER_0_470 VPWR VGND sg13g2_decap_8
XFILLER_1_993 VPWR VGND sg13g2_decap_8
XFILLER_48_474 VPWR VGND sg13g2_decap_8
XFILLER_44_691 VPWR VGND sg13g2_decap_8
Xu_custom_cells.u_mux1.mux_inv_inst _286_/B2 VPWR VGND _574_/Q _573_/Q _572_/Q mux_inv
XFILLER_6_1020 VPWR VGND sg13g2_decap_8
XFILLER_42_606 VPWR VGND sg13g2_decap_8
XFILLER_2_746 VPWR VGND sg13g2_decap_8
XFILLER_45_422 VPWR VGND sg13g2_decap_8
XFILLER_14_875 VPWR VGND sg13g2_decap_8
XFILLER_41_694 VPWR VGND sg13g2_decap_8
X_524_ _524_/Q _626_/CLK _524_/D fanout69/X VPWR VGND sg13g2_dfrbpq_1
X_455_ _455_/Y _456_/A _456_/B VPWR VGND sg13g2_xnor2_1
X_386_ _551_/D _550_/Q _551_/Q _398_/S VPWR VGND sg13g2_mux2_1
XFILLER_5_562 VPWR VGND sg13g2_decap_8
XFILLER_1_790 VPWR VGND sg13g2_decap_8
XFILLER_48_271 VPWR VGND sg13g2_decap_8
XFILLER_20_823 VPWR VGND sg13g2_decap_8
XFILLER_47_709 VPWR VGND sg13g2_decap_8
XFILLER_11_812 VPWR VGND sg13g2_decap_8
X_240_ _240_/X _655_/Q _254_/B VPWR VGND sg13g2_and2_1
XFILLER_11_889 VPWR VGND sg13g2_decap_8
XFILLER_7_849 VPWR VGND sg13g2_decap_8
XFILLER_2_543 VPWR VGND sg13g2_decap_8
XFILLER_45_252 VPWR VGND sg13g2_decap_4
XFILLER_46_753 VPWR VGND sg13g2_decap_8
X_507_ _507_/Q _579_/CLK _507_/D fanout72/X VPWR VGND sg13g2_dfrbpq_1
X_438_ _438_/Y _460_/A _444_/B VPWR VGND sg13g2_xnor2_1
X_369_ _534_/D _533_/Q _534_/Q _407_/S VPWR VGND sg13g2_mux2_1
XFILLER_28_797 VPWR VGND sg13g2_decap_8
XFILLER_43_701 VPWR VGND sg13g2_fill_2
XFILLER_43_723 VPWR VGND sg13g2_decap_8
X_223_ _223_/Y _650_/Q VPWR VGND sg13g2_inv_1
XFILLER_7_646 VPWR VGND sg13g2_decap_8
XFILLER_3_885 VPWR VGND sg13g2_decap_8
XFILLER_34_756 VPWR VGND sg13g2_decap_8
XFILLER_46_594 VPWR VGND sg13g2_decap_8
XFILLER_13_907 VPWR VGND sg13g2_decap_8
XFILLER_25_756 VPWR VGND sg13g2_decap_8
XFILLER_4_649 VPWR VGND sg13g2_decap_8
XFILLER_0_855 VPWR VGND sg13g2_decap_8
Xu_clkbuf_analog_pin2.u_buf analog_pin2 _444_/A VPWR VGND sg13g2_buf_16
XFILLER_48_859 VPWR VGND sg13g2_decap_8
XFILLER_47_303 VPWR VGND sg13g2_decap_8
XFILLER_16_756 VPWR VGND sg13g2_decap_8
XFILLER_43_575 VPWR VGND sg13g2_decap_8
XFILLER_12_973 VPWR VGND sg13g2_decap_8
XFILLER_8_966 VPWR VGND sg13g2_decap_8
XFILLER_7_432 VPWR VGND sg13g2_decap_8
XFILLER_3_682 VPWR VGND sg13g2_decap_8
XFILLER_48_1013 VPWR VGND sg13g2_decap_8
XFILLER_39_826 VPWR VGND sg13g2_decap_8
XFILLER_9_60 VPWR VGND sg13g2_fill_2
XFILLER_1_608 VPWR VGND sg13g2_decap_8
XFILLER_30_770 VPWR VGND sg13g2_decap_8
XFILLER_45_807 VPWR VGND sg13g2_decap_8
XFILLER_5_947 VPWR VGND sg13g2_decap_8
XFILLER_4_446 VPWR VGND sg13g2_decap_4
XFILLER_0_652 VPWR VGND sg13g2_decap_8
XFILLER_48_656 VPWR VGND sg13g2_decap_8
XFILLER_12_770 VPWR VGND sg13g2_decap_8
XFILLER_8_763 VPWR VGND sg13g2_decap_8
XFILLER_7_240 VPWR VGND sg13g2_decap_8
XFILLER_15_0 VPWR VGND sg13g2_fill_1
Xu_custom_cells.u_latch0.latch_inst _284_/B2 _282_/B2 VGND VPWR _577_/Q latch
XFILLER_2_928 VPWR VGND sg13g2_decap_8
XFILLER_45_604 VPWR VGND sg13g2_decap_8
X_540_ _540_/Q _656_/CLK _540_/D fanout70/X VPWR VGND sg13g2_dfrbpq_1
XFILLER_26_840 VPWR VGND sg13g2_decap_8
XFILLER_26_851 VPWR VGND sg13g2_fill_1
X_471_ _471_/Q _652_/CLK _471_/D fanout81/X VPWR VGND sg13g2_dfrbpq_1
XFILLER_5_744 VPWR VGND sg13g2_decap_8
XFILLER_1_972 VPWR VGND sg13g2_decap_8
XFILLER_49_943 VPWR VGND sg13g2_decap_8
XFILLER_49_910 VPWR VGND sg13g2_decap_8
XFILLER_49_965 VPWR VGND sg13g2_decap_4
XFILLER_49_954 VPWR VGND sg13g2_fill_1
XFILLER_48_453 VPWR VGND sg13g2_decap_8
XFILLER_44_670 VPWR VGND sg13g2_decap_8
XFILLER_2_725 VPWR VGND sg13g2_decap_8
XFILLER_45_401 VPWR VGND sg13g2_decap_8
XFILLER_45_478 VPWR VGND sg13g2_decap_8
X_523_ _523_/Q _626_/CLK _523_/D fanout68/X VPWR VGND sg13g2_dfrbpq_1
XFILLER_14_854 VPWR VGND sg13g2_decap_8
XFILLER_41_673 VPWR VGND sg13g2_decap_8
X_454_ _454_/Y _456_/A _456_/B VPWR VGND sg13g2_xnor2_1
X_385_ _550_/D _549_/Q _550_/Q _398_/S VPWR VGND sg13g2_mux2_1
XFILLER_12_1015 VPWR VGND sg13g2_decap_8
XFILLER_5_541 VPWR VGND sg13g2_decap_8
XFILLER_49_784 VPWR VGND sg13g2_decap_8
XFILLER_20_802 VPWR VGND sg13g2_decap_8
XFILLER_11_868 VPWR VGND sg13g2_decap_8
XFILLER_2_522 VPWR VGND sg13g2_decap_8
XFILLER_7_828 VPWR VGND sg13g2_decap_8
XFILLER_2_599 VPWR VGND sg13g2_decap_8
XFILLER_45_297 VPWR VGND sg13g2_decap_4
X_506_ _506_/Q _541_/CLK _506_/D fanout84/X VPWR VGND sg13g2_dfrbpq_1
XFILLER_46_732 VPWR VGND sg13g2_decap_8
X_437_ _602_/D _291_/B _295_/Y _602_/Q VPWR VGND sg13g2_a21o_1
X_368_ _533_/D _532_/Q _533_/Q _407_/S VPWR VGND sg13g2_mux2_1
X_299_ _300_/B _218_/Y _297_/B _304_/A VPWR VGND sg13g2_o21ai_1
XFILLER_6_894 VPWR VGND sg13g2_decap_8
XFILLER_49_581 VPWR VGND sg13g2_decap_8
XFILLER_28_776 VPWR VGND sg13g2_decap_8
XFILLER_43_779 VPWR VGND sg13g2_decap_8
X_222_ _222_/Y _604_/Q VPWR VGND sg13g2_inv_1
XFILLER_7_625 VPWR VGND sg13g2_decap_8
XFILLER_2_374 VPWR VGND sg13g2_decap_8
XFILLER_3_864 VPWR VGND sg13g2_decap_8
XFILLER_6_179 VPWR VGND sg13g2_decap_8
XFILLER_2_385 VPWR VGND sg13g2_fill_2
XFILLER_19_798 VPWR VGND sg13g2_decap_8
XFILLER_46_573 VPWR VGND sg13g2_decap_8
XFILLER_45_0 VPWR VGND sg13g2_fill_1
XFILLER_6_691 VPWR VGND sg13g2_decap_8
XFILLER_33_790 VPWR VGND sg13g2_decap_8
XFILLER_4_628 VPWR VGND sg13g2_decap_8
XFILLER_0_834 VPWR VGND sg13g2_decap_8
XFILLER_48_838 VPWR VGND sg13g2_decap_8
XFILLER_47_359 VPWR VGND sg13g2_decap_8
XFILLER_31_749 VPWR VGND sg13g2_decap_8
XFILLER_43_554 VPWR VGND sg13g2_decap_8
XFILLER_12_952 VPWR VGND sg13g2_decap_8
XFILLER_8_945 VPWR VGND sg13g2_decap_8
XFILLER_2_160 VPWR VGND sg13g2_fill_2
XFILLER_39_805 VPWR VGND sg13g2_decap_8
XFILLER_3_661 VPWR VGND sg13g2_decap_8
XFILLER_0_1016 VPWR VGND sg13g2_decap_8
XFILLER_0_1027 VPWR VGND sg13g2_fill_2
XFILLER_22_749 VPWR VGND sg13g2_fill_1
Xdelaybuf_26_clk delaybuf_27_clk/A delaybuf_26_clk/A VPWR VGND sg13g2_buf_16
XFILLER_5_926 VPWR VGND sg13g2_decap_8
XFILLER_0_631 VPWR VGND sg13g2_decap_8
Xdelaybuf_17_clk delaybuf_18_clk/A clkbuf_0_clk/X VPWR VGND sg13g2_buf_16
XFILLER_48_635 VPWR VGND sg13g2_decap_8
XFILLER_43_384 VPWR VGND sg13g2_decap_8
XFILLER_27_819 VPWR VGND sg13g2_decap_8
XFILLER_4_992 VPWR VGND sg13g2_decap_8
XFILLER_30_27 VPWR VGND sg13g2_fill_2
Xu_clkbuf_analog_pin1.u_buf analog_pin1 _282_/A1 VPWR VGND sg13g2_buf_16
XFILLER_2_907 VPWR VGND sg13g2_decap_8
XFILLER_18_819 VPWR VGND sg13g2_decap_8
X_470_ _470_/Q _659_/CLK _470_/D fanout81/X VPWR VGND sg13g2_dfrbpq_1
XFILLER_5_723 VPWR VGND sg13g2_decap_8
XFILLER_1_951 VPWR VGND sg13g2_decap_8
XFILLER_48_432 VPWR VGND sg13g2_decap_8
XFILLER_17_885 VPWR VGND sg13g2_decap_4
X_599_ _599_/Q _627_/CLK _599_/D fanout64/X VPWR VGND sg13g2_dfrbpq_1
XFILLER_23_844 VPWR VGND sg13g2_decap_8
XFILLER_2_704 VPWR VGND sg13g2_decap_8
XFILLER_14_833 VPWR VGND sg13g2_decap_8
XFILLER_45_457 VPWR VGND sg13g2_decap_8
X_522_ _522_/Q _571_/CLK _522_/D fanout82/X VPWR VGND sg13g2_dfrbpq_1
X_453_ _453_/Y _459_/A _456_/B VPWR VGND sg13g2_xnor2_1
XFILLER_41_652 VPWR VGND sg13g2_decap_8
X_384_ _549_/D _548_/Q _549_/Q _397_/S VPWR VGND sg13g2_mux2_1
XFILLER_5_597 VPWR VGND sg13g2_decap_8
XFILLER_5_520 VPWR VGND sg13g2_decap_8
XFILLER_49_763 VPWR VGND sg13g2_decap_8
Xclkbuf_4_0_0_clk_regs clkbuf_4_0_0_clk_regs/X clkbuf_0_clk_regs/X VPWR VGND sg13g2_buf_8
XFILLER_9_892 VPWR VGND sg13g2_decap_8
XFILLER_11_847 VPWR VGND sg13g2_decap_8
XFILLER_7_807 VPWR VGND sg13g2_decap_8
XFILLER_2_501 VPWR VGND sg13g2_decap_8
XFILLER_2_578 VPWR VGND sg13g2_decap_8
XFILLER_46_711 VPWR VGND sg13g2_decap_8
XFILLER_45_276 VPWR VGND sg13g2_decap_8
X_505_ _505_/Q _534_/CLK _505_/D fanout86/X VPWR VGND sg13g2_dfrbpq_1
X_436_ _601_/D _600_/Q _601_/Q _436_/S VPWR VGND sg13g2_mux2_1
XFILLER_46_788 VPWR VGND sg13g2_decap_8
X_367_ _532_/D _531_/Q _532_/Q _407_/S VPWR VGND sg13g2_mux2_1
X_298_ _302_/B _469_/Q _470_/Q _311_/S VPWR VGND sg13g2_nand3_1
XFILLER_6_873 VPWR VGND sg13g2_decap_8
XFILLER_37_777 VPWR VGND sg13g2_decap_8
XFILLER_37_799 VPWR VGND sg13g2_decap_8
XFILLER_3_1025 VPWR VGND sg13g2_decap_4
XFILLER_49_560 VPWR VGND sg13g2_decap_8
XFILLER_16_917 VPWR VGND sg13g2_decap_8
XFILLER_16_928 VPWR VGND sg13g2_fill_2
XFILLER_43_758 VPWR VGND sg13g2_decap_8
X_221_ _647_/D _270_/S VPWR VGND sg13g2_inv_1
XFILLER_7_604 VPWR VGND sg13g2_decap_8
XFILLER_2_353 VPWR VGND sg13g2_decap_8
XFILLER_3_843 VPWR VGND sg13g2_decap_8
XFILLER_19_777 VPWR VGND sg13g2_decap_8
XFILLER_46_552 VPWR VGND sg13g2_decap_8
XFILLER_15_961 VPWR VGND sg13g2_decap_8
X_419_ _584_/D _610_/D _584_/Q _436_/S VPWR VGND sg13g2_mux2_1
XFILLER_6_670 VPWR VGND sg13g2_decap_8
Xclkbuf_leaf_5_clk _452_/B delaybuf_16_clk/X VPWR VGND sg13g2_buf_8
Xclkbuf_5_19__f_clk_regs _612_/CLK clkbuf_4_9_0_clk_regs/X VPWR VGND sg13g2_buf_16
XFILLER_4_607 VPWR VGND sg13g2_decap_8
XFILLER_0_813 VPWR VGND sg13g2_decap_8
XFILLER_48_817 VPWR VGND sg13g2_decap_8
XFILLER_47_338 VPWR VGND sg13g2_decap_8
XFILLER_12_931 VPWR VGND sg13g2_decap_8
XFILLER_24_791 VPWR VGND sg13g2_decap_8
XFILLER_3_640 VPWR VGND sg13g2_decap_8
XFILLER_8_924 VPWR VGND sg13g2_decap_8
XFILLER_7_467 VPWR VGND sg13g2_decap_8
XFILLER_7_412 VPWR VGND sg13g2_fill_2
XFILLER_15_791 VPWR VGND sg13g2_decap_8
XFILLER_9_62 VPWR VGND sg13g2_fill_1
XFILLER_0_109 VPWR VGND sg13g2_fill_2
XFILLER_21_794 VPWR VGND sg13g2_decap_8
XFILLER_5_905 VPWR VGND sg13g2_decap_8
XFILLER_0_610 VPWR VGND sg13g2_decap_8
XFILLER_0_687 VPWR VGND sg13g2_decap_8
Xclkbuf_4_13_0_clk_regs clkbuf_4_13_0_clk_regs/X clkbuf_0_clk_regs/X VPWR VGND sg13g2_buf_8
XFILLER_48_614 VPWR VGND sg13g2_decap_8
XFILLER_44_831 VPWR VGND sg13g2_decap_8
XFILLER_15_1025 VPWR VGND sg13g2_decap_4
XFILLER_8_798 VPWR VGND sg13g2_decap_8
XFILLER_4_971 VPWR VGND sg13g2_decap_8
XFILLER_35_820 VPWR VGND sg13g2_decap_4
XFILLER_45_639 VPWR VGND sg13g2_decap_8
XFILLER_41_834 VPWR VGND sg13g2_decap_8
XFILLER_1_930 VPWR VGND sg13g2_decap_8
XFILLER_5_779 VPWR VGND sg13g2_decap_8
XFILLER_5_702 VPWR VGND sg13g2_decap_8
XFILLER_0_484 VPWR VGND sg13g2_decap_8
XFILLER_48_411 VPWR VGND sg13g2_decap_8
X_598_ _598_/Q _627_/CLK _598_/D fanout64/X VPWR VGND sg13g2_dfrbpq_1
XFILLER_48_488 VPWR VGND sg13g2_decap_8
XFILLER_20_0 VPWR VGND sg13g2_fill_2
XFILLER_23_823 VPWR VGND sg13g2_decap_8
XFILLER_14_812 VPWR VGND sg13g2_decap_8
XFILLER_41_631 VPWR VGND sg13g2_decap_8
XFILLER_45_436 VPWR VGND sg13g2_decap_8
X_521_ _521_/Q _533_/CLK _521_/D fanout82/X VPWR VGND sg13g2_dfrbpq_1
X_452_ _452_/Y _459_/A _452_/B VPWR VGND sg13g2_xnor2_1
X_383_ _548_/D _547_/Q _548_/Q _397_/S VPWR VGND sg13g2_mux2_1
XFILLER_14_889 VPWR VGND sg13g2_decap_8
Xu_clkbuf_analog_pin0.u_buf analog_pin0 _280_/A0 VPWR VGND sg13g2_buf_16
XFILLER_5_576 VPWR VGND sg13g2_decap_8
XFILLER_49_742 VPWR VGND sg13g2_decap_8
XFILLER_48_285 VPWR VGND sg13g2_decap_8
XFILLER_20_837 VPWR VGND sg13g2_decap_8
XFILLER_9_871 VPWR VGND sg13g2_decap_8
XFILLER_11_826 VPWR VGND sg13g2_decap_8
XFILLER_2_557 VPWR VGND sg13g2_decap_8
XFILLER_46_767 VPWR VGND sg13g2_decap_8
X_504_ _504_/Q _581_/CLK _504_/D fanout86/X VPWR VGND sg13g2_dfrbpq_1
X_435_ _600_/D _599_/Q _600_/Q _436_/S VPWR VGND sg13g2_mux2_1
X_366_ _531_/D _530_/Q _531_/Q _366_/S VPWR VGND sg13g2_mux2_1
X_297_ _469_/D _469_/Q _297_/B VPWR VGND sg13g2_xnor2_1
XFILLER_6_852 VPWR VGND sg13g2_decap_8
XFILLER_37_756 VPWR VGND sg13g2_decap_8
XFILLER_3_1004 VPWR VGND sg13g2_decap_8
Xclkbuf_5_18__f_clk_regs _626_/CLK clkbuf_4_9_0_clk_regs/X VPWR VGND sg13g2_buf_16
XFILLER_43_737 VPWR VGND sg13g2_decap_8
X_220_ _220_/Y _472_/Q VPWR VGND sg13g2_inv_1
XFILLER_3_822 VPWR VGND sg13g2_decap_8
XFILLER_3_899 VPWR VGND sg13g2_decap_8
XFILLER_15_940 VPWR VGND sg13g2_decap_8
XFILLER_19_756 VPWR VGND sg13g2_decap_8
XFILLER_42_781 VPWR VGND sg13g2_decap_8
X_418_ _583_/D _609_/D _610_/D _432_/S VPWR VGND sg13g2_mux2_1
X_349_ _514_/D _513_/Q _514_/Q _349_/S VPWR VGND sg13g2_mux2_1
XFILLER_0_869 VPWR VGND sg13g2_decap_8
XFILLER_47_317 VPWR VGND sg13g2_decap_8
XFILLER_12_910 VPWR VGND sg13g2_decap_8
XFILLER_12_987 VPWR VGND sg13g2_decap_8
XFILLER_23_72 VPWR VGND sg13g2_fill_1
XFILLER_24_770 VPWR VGND sg13g2_decap_8
XFILLER_43_589 VPWR VGND sg13g2_decap_8
XFILLER_8_903 VPWR VGND sg13g2_decap_8
XFILLER_7_446 VPWR VGND sg13g2_decap_8
XFILLER_48_1027 VPWR VGND sg13g2_fill_2
XFILLER_2_162 VPWR VGND sg13g2_fill_1
XFILLER_3_696 VPWR VGND sg13g2_decap_8
XFILLER_15_770 VPWR VGND sg13g2_decap_8
XFILLER_46_383 VPWR VGND sg13g2_decap_8
XFILLER_30_784 VPWR VGND sg13g2_decap_8
XFILLER_38_840 VPWR VGND sg13g2_decap_8
XFILLER_38_851 VPWR VGND sg13g2_fill_1
XFILLER_21_773 VPWR VGND sg13g2_decap_8
XFILLER_0_666 VPWR VGND sg13g2_decap_8
XFILLER_44_810 VPWR VGND sg13g2_decap_8
XFILLER_12_784 VPWR VGND sg13g2_decap_8
XFILLER_8_777 VPWR VGND sg13g2_decap_8
XFILLER_7_254 VPWR VGND sg13g2_fill_1
XFILLER_3_493 VPWR VGND sg13g2_decap_8
XFILLER_7_287 VPWR VGND sg13g2_decap_8
XFILLER_4_950 VPWR VGND sg13g2_decap_8
XFILLER_47_681 VPWR VGND sg13g2_decap_8
XFILLER_46_180 VPWR VGND sg13g2_fill_2
XFILLER_41_813 VPWR VGND sg13g2_decap_8
XFILLER_45_618 VPWR VGND sg13g2_decap_8
Xclkbuf_regs_1_clk clkbuf_regs_1_clk/X _256_/Y VPWR VGND sg13g2_buf_16
XFILLER_5_758 VPWR VGND sg13g2_decap_8
XFILLER_0_463 VPWR VGND sg13g2_decap_8
XFILLER_1_986 VPWR VGND sg13g2_decap_8
XFILLER_49_924 VPWR VGND sg13g2_fill_2
XFILLER_48_467 VPWR VGND sg13g2_decap_8
XFILLER_32_802 VPWR VGND sg13g2_fill_1
XFILLER_32_813 VPWR VGND sg13g2_fill_2
XFILLER_44_684 VPWR VGND sg13g2_decap_8
X_597_ _626_/D _628_/CLK _597_/D fanout65/X VPWR VGND sg13g2_dfrbpq_1
XFILLER_6_1013 VPWR VGND sg13g2_decap_8
XFILLER_13_0 VPWR VGND sg13g2_fill_1
XFILLER_23_802 VPWR VGND sg13g2_decap_8
XFILLER_2_739 VPWR VGND sg13g2_decap_8
XFILLER_45_415 VPWR VGND sg13g2_decap_8
X_520_ _520_/Q _571_/CLK _520_/D fanout82/X VPWR VGND sg13g2_dfrbpq_1
XFILLER_14_868 VPWR VGND sg13g2_decap_8
XFILLER_41_610 VPWR VGND sg13g2_decap_8
X_451_ _451_/Y _456_/A _452_/B VPWR VGND sg13g2_xnor2_1
X_382_ _547_/D _546_/Q _547_/Q _397_/S VPWR VGND sg13g2_mux2_1
XFILLER_31_72 VPWR VGND sg13g2_fill_1
XFILLER_41_687 VPWR VGND sg13g2_decap_8
XFILLER_5_555 VPWR VGND sg13g2_decap_8
XFILLER_0_282 VPWR VGND sg13g2_fill_2
XFILLER_1_783 VPWR VGND sg13g2_decap_8
XFILLER_49_721 VPWR VGND sg13g2_decap_8
X_649_ _649_/Q _649_/CLK _649_/D fanout77/X VPWR VGND sg13g2_dfrbpq_1
XFILLER_49_798 VPWR VGND sg13g2_decap_8
XFILLER_20_816 VPWR VGND sg13g2_decap_8
Xclkbuf_5_17__f_clk_regs _616_/CLK clkbuf_4_8_0_clk_regs/X VPWR VGND sg13g2_buf_16
XFILLER_9_850 VPWR VGND sg13g2_decap_8
Xu_custom_cells.u_mux0.mux_inst VGND VPWR _288_/B2 _570_/Q _574_/Q _571_/Q mux
XFILLER_11_805 VPWR VGND sg13g2_decap_8
XFILLER_2_536 VPWR VGND sg13g2_decap_8
XFILLER_45_256 VPWR VGND sg13g2_fill_2
X_503_ _503_/Q _581_/CLK _503_/D fanout86/X VPWR VGND sg13g2_dfrbpq_1
XFILLER_46_746 VPWR VGND sg13g2_decap_8
X_434_ _599_/D _598_/Q _599_/Q _436_/S VPWR VGND sg13g2_mux2_1
X_365_ _530_/D _529_/Q _530_/Q _366_/S VPWR VGND sg13g2_mux2_1
X_296_ _297_/B _295_/A _295_/B _311_/S VPWR VGND sg13g2_o21ai_1
XFILLER_10_893 VPWR VGND sg13g2_decap_8
XFILLER_6_831 VPWR VGND sg13g2_decap_8
XFILLER_1_580 VPWR VGND sg13g2_decap_8
XFILLER_49_595 VPWR VGND sg13g2_decap_8
XFILLER_43_716 VPWR VGND sg13g2_decap_8
XFILLER_2_322 VPWR VGND sg13g2_fill_2
XFILLER_3_801 VPWR VGND sg13g2_decap_8
XFILLER_7_639 VPWR VGND sg13g2_decap_8
XFILLER_2_333 VPWR VGND sg13g2_fill_2
XFILLER_3_878 VPWR VGND sg13g2_decap_8
XFILLER_34_749 VPWR VGND sg13g2_decap_8
XFILLER_46_587 VPWR VGND sg13g2_decap_8
XFILLER_42_760 VPWR VGND sg13g2_decap_8
X_417_ _582_/D _608_/D _609_/D _429_/S VPWR VGND sg13g2_mux2_1
X_348_ _513_/D _512_/Q _513_/Q _349_/S VPWR VGND sg13g2_mux2_1
X_279_ _279_/Y _281_/A _279_/B VPWR VGND sg13g2_nor2_1
XFILLER_49_392 VPWR VGND sg13g2_decap_8
XFILLER_25_749 VPWR VGND sg13g2_decap_8
XFILLER_0_848 VPWR VGND sg13g2_decap_8
XFILLER_16_749 VPWR VGND sg13g2_decap_8
XFILLER_43_568 VPWR VGND sg13g2_decap_8
XFILLER_12_966 VPWR VGND sg13g2_decap_8
XFILLER_8_959 VPWR VGND sg13g2_decap_8
XFILLER_7_425 VPWR VGND sg13g2_decap_8
XFILLER_7_414 VPWR VGND sg13g2_fill_1
XFILLER_3_675 VPWR VGND sg13g2_decap_8
XFILLER_39_819 VPWR VGND sg13g2_decap_8
Xu_custom_cells.u_latmux.SwitchMatrixMultiplexer_inst _576_/Q VGND VPWR _288_/B2 _286_/B2
+ _282_/B2 _575_/Q SwitchMatrixMultiplexer
XFILLER_46_362 VPWR VGND sg13g2_decap_8
XFILLER_30_763 VPWR VGND sg13g2_decap_8
XFILLER_9_1011 VPWR VGND sg13g2_decap_8
XFILLER_4_417 VPWR VGND sg13g2_fill_2
XFILLER_0_645 VPWR VGND sg13g2_decap_8
XFILLER_48_649 VPWR VGND sg13g2_decap_8
XFILLER_34_72 VPWR VGND sg13g2_fill_1
XFILLER_43_398 VPWR VGND sg13g2_decap_8
XFILLER_12_763 VPWR VGND sg13g2_decap_8
XFILLER_8_756 VPWR VGND sg13g2_decap_8
XFILLER_47_660 VPWR VGND sg13g2_decap_8
XFILLER_26_833 VPWR VGND sg13g2_decap_8
XFILLER_5_737 VPWR VGND sg13g2_decap_8
XFILLER_0_442 VPWR VGND sg13g2_decap_8
XFILLER_1_965 VPWR VGND sg13g2_decap_8
XFILLER_49_903 VPWR VGND sg13g2_decap_8
XFILLER_17_833 VPWR VGND sg13g2_decap_8
XFILLER_49_936 VPWR VGND sg13g2_decap_8
XFILLER_48_446 VPWR VGND sg13g2_decap_8
XFILLER_44_663 VPWR VGND sg13g2_decap_8
X_596_ _596_/Q _612_/CLK _596_/D fanout65/X VPWR VGND sg13g2_dfrbpq_1
Xclkbuf_5_16__f_clk_regs _628_/CLK clkbuf_4_8_0_clk_regs/X VPWR VGND sg13g2_buf_16
XFILLER_1_217 VPWR VGND sg13g2_fill_2
XFILLER_2_718 VPWR VGND sg13g2_decap_8
XFILLER_14_847 VPWR VGND sg13g2_decap_8
XFILLER_41_666 VPWR VGND sg13g2_decap_8
X_450_ _450_/Y _456_/A _452_/B VPWR VGND sg13g2_xnor2_1
X_381_ _546_/D _545_/Q _546_/Q _397_/S VPWR VGND sg13g2_mux2_1
XFILLER_12_1008 VPWR VGND sg13g2_decap_8
XFILLER_5_534 VPWR VGND sg13g2_decap_8
XFILLER_1_762 VPWR VGND sg13g2_decap_8
XFILLER_49_777 VPWR VGND sg13g2_decap_8
XFILLER_49_700 VPWR VGND sg13g2_decap_8
X_648_ _648_/Q _648_/CLK _648_/D fanout76/X VPWR VGND sg13g2_dfrbpq_1
X_579_ _579_/Q _579_/CLK _579_/D fanout84/X VPWR VGND sg13g2_dfrbpq_1
XFILLER_2_515 VPWR VGND sg13g2_decap_8
Xdelaybuf_0_clk delaybuf_0_clk/X u_delay_line/clk VPWR VGND sg13g2_buf_16
X_502_ _502_/Q _607_/CLK _502_/D fanout86/X VPWR VGND sg13g2_dfrbpq_1
X_433_ _598_/D _626_/D _598_/Q _436_/S VPWR VGND sg13g2_mux2_1
XFILLER_46_725 VPWR VGND sg13g2_decap_8
XFILLER_10_872 VPWR VGND sg13g2_decap_8
X_364_ _529_/D _528_/Q _529_/Q _376_/S VPWR VGND sg13g2_mux2_1
X_295_ _295_/Y _295_/A _295_/B VPWR VGND sg13g2_nor2_1
XFILLER_6_810 VPWR VGND sg13g2_decap_8
XFILLER_6_887 VPWR VGND sg13g2_decap_8
XFILLER_5_397 VPWR VGND sg13g2_fill_2
XFILLER_5_342 VPWR VGND sg13g2_decap_4
XFILLER_49_574 VPWR VGND sg13g2_decap_8
XFILLER_28_769 VPWR VGND sg13g2_decap_8
XFILLER_7_618 VPWR VGND sg13g2_decap_8
XFILLER_3_857 VPWR VGND sg13g2_decap_8
XFILLER_2_367 VPWR VGND sg13g2_decap_8
XFILLER_27_791 VPWR VGND sg13g2_decap_8
X_416_ _581_/D _580_/Q _608_/D _416_/S VPWR VGND sg13g2_mux2_1
XFILLER_46_566 VPWR VGND sg13g2_decap_8
X_347_ _512_/D _511_/Q _512_/Q _349_/S VPWR VGND sg13g2_mux2_1
X_278_ _634_/D _612_/Q _626_/Q _278_/S VPWR VGND sg13g2_mux2_1
XFILLER_6_684 VPWR VGND sg13g2_decap_8
XFILLER_49_371 VPWR VGND sg13g2_decap_8
XFILLER_18_791 VPWR VGND sg13g2_decap_8
XFILLER_33_783 VPWR VGND sg13g2_decap_8
XFILLER_0_827 VPWR VGND sg13g2_decap_8
XFILLER_12_945 VPWR VGND sg13g2_decap_8
XFILLER_8_938 VPWR VGND sg13g2_decap_8
XFILLER_3_0 VPWR VGND sg13g2_fill_1
XFILLER_3_654 VPWR VGND sg13g2_decap_8
XFILLER_0_1009 VPWR VGND sg13g2_decap_8
XFILLER_46_341 VPWR VGND sg13g2_decap_8
XFILLER_47_853 VPWR VGND sg13g2_fill_1
XFILLER_47_842 VPWR VGND sg13g2_decap_8
XFILLER_0_89 VPWR VGND sg13g2_fill_2
XFILLER_7_982 VPWR VGND sg13g2_decap_8
XFILLER_5_919 VPWR VGND sg13g2_decap_8
XFILLER_0_624 VPWR VGND sg13g2_decap_8
XFILLER_48_628 VPWR VGND sg13g2_decap_8
XFILLER_43_333 VPWR VGND sg13g2_fill_2
XFILLER_43_377 VPWR VGND sg13g2_decap_8
XFILLER_44_845 VPWR VGND sg13g2_decap_8
Xclkbuf_5_15__f_clk_regs _557_/CLK clkbuf_4_7_0_clk_regs/X VPWR VGND sg13g2_buf_16
XFILLER_7_267 VPWR VGND sg13g2_decap_4
XFILLER_4_985 VPWR VGND sg13g2_decap_8
XFILLER_26_812 VPWR VGND sg13g2_decap_8
XFILLER_41_848 VPWR VGND sg13g2_decap_4
XFILLER_5_716 VPWR VGND sg13g2_decap_8
XFILLER_0_421 VPWR VGND sg13g2_decap_8
XFILLER_0_498 VPWR VGND sg13g2_decap_8
XFILLER_1_944 VPWR VGND sg13g2_decap_8
XFILLER_48_425 VPWR VGND sg13g2_decap_8
XFILLER_17_812 VPWR VGND sg13g2_decap_8
XFILLER_17_889 VPWR VGND sg13g2_fill_1
XFILLER_44_642 VPWR VGND sg13g2_decap_8
X_595_ _624_/D _616_/CLK _595_/D fanout67/X VPWR VGND sg13g2_dfrbpq_1
XFILLER_4_782 VPWR VGND sg13g2_decap_8
XFILLER_23_837 VPWR VGND sg13g2_decap_8
Xclkbuf_4_12_0_clk_regs clkbuf_4_12_0_clk_regs/X clkbuf_0_clk_regs/X VPWR VGND sg13g2_buf_8
XFILLER_14_826 VPWR VGND sg13g2_decap_8
XFILLER_41_645 VPWR VGND sg13g2_decap_8
X_380_ _545_/D _544_/Q _545_/Q _391_/S VPWR VGND sg13g2_mux2_1
Xoutput30 uo_out[0] _280_/X VPWR VGND sg13g2_buf_1
XFILLER_0_284 VPWR VGND sg13g2_fill_1
XFILLER_0_295 VPWR VGND sg13g2_decap_8
XFILLER_1_741 VPWR VGND sg13g2_decap_8
XFILLER_49_756 VPWR VGND sg13g2_decap_8
X_578_ _605_/D _579_/CLK _578_/D fanout72/X VPWR VGND sg13g2_dfrbpq_1
X_647_ _647_/Q _647_/CLK _647_/D fanout76/X VPWR VGND sg13g2_dfrbpq_1
XFILLER_48_299 VPWR VGND sg13g2_decap_8
XFILLER_9_885 VPWR VGND sg13g2_decap_8
.ends
