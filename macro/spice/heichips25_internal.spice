* NGSPICE file created from heichips25_internal.ext - technology: ihp-sg13g2

* Black-box entry subcircuit for sg13g2_decap_8 abstract view
.subckt sg13g2_decap_8 VDD VSS
.ends

* Black-box entry subcircuit for sg13g2_fill_1 abstract view
.subckt sg13g2_fill_1 VDD VSS
.ends

* Black-box entry subcircuit for sg13g2_dfrbpq_1 abstract view
.subckt sg13g2_dfrbpq_1 Q CLK D RESET_B VDD VSS
.ends

* Black-box entry subcircuit for sg13g2_mux2_1 abstract view
.subckt sg13g2_mux2_1 X A0 A1 S VDD VSS
.ends

* Black-box entry subcircuit for sg13g2_nand2_1 abstract view
.subckt sg13g2_nand2_1 Y A B VDD VSS
.ends

* Black-box entry subcircuit for sg13g2_fill_2 abstract view
.subckt sg13g2_fill_2 VDD VSS
.ends

* Black-box entry subcircuit for sg13g2_and2_1 abstract view
.subckt sg13g2_and2_1 X A B VDD VSS
.ends

* Black-box entry subcircuit for sg13g2_buf_16 abstract view
.subckt sg13g2_buf_16 X A VDD VSS
.ends

* Black-box entry subcircuit for sg13g2_nand4_1 abstract view
.subckt sg13g2_nand4_1 Y A B C D VDD VSS
.ends

* Black-box entry subcircuit for sg13g2_decap_4 abstract view
.subckt sg13g2_decap_4 VDD VSS
.ends

* Black-box entry subcircuit for sg13g2_antennanp abstract view
.subckt sg13g2_antennanp A VDD VSS
.ends

* Black-box entry subcircuit for sg13g2_buf_1 abstract view
.subckt sg13g2_buf_1 X A VDD VSS
.ends

* Black-box entry subcircuit for sg13g2_o21ai_1 abstract view
.subckt sg13g2_o21ai_1 Y A1 A2 B1 VDD VSS
.ends

* Black-box entry subcircuit for sg13g2_or2_1 abstract view
.subckt sg13g2_or2_1 X A B VDD VSS
.ends

* Black-box entry subcircuit for sg13g2_buf_8 abstract view
.subckt sg13g2_buf_8 X A VDD VSS
.ends

* Black-box entry subcircuit for sg13g2_dlygate4sd3_1 abstract view
.subckt sg13g2_dlygate4sd3_1 X A VDD VSS
.ends

* Black-box entry subcircuit for sg13g2_nand3_1 abstract view
.subckt sg13g2_nand3_1 Y A B C VDD VSS
.ends

* Black-box entry subcircuit for sg13g2_nor2b_1 abstract view
.subckt sg13g2_nor2b_1 Y A B_N VDD VSS
.ends

* Black-box entry subcircuit for sg13g2_xnor2_1 abstract view
.subckt sg13g2_xnor2_1 Y A B VDD VSS
.ends

* Black-box entry subcircuit for delay_line abstract view
.subckt delay_line VDD VSS clk clk_delayed reset sel[0] sel[1] sel[2] sel[3] trim[0]
+ trim[10] trim[11] trim[12] trim[13] trim[14] trim[15] trim[16] trim[17] trim[18]
+ trim[19] trim[1] trim[20] trim[21] trim[22] trim[23] trim[2] trim[3] trim[4] trim[5]
+ trim[6] trim[7] trim[8] trim[9]
.ends

* Black-box entry subcircuit for sg13g2_mux4_1 abstract view
.subckt sg13g2_mux4_1 X A0 A1 A2 A3 S0 S1 VDD VSS
.ends

* Black-box entry subcircuit for sg13g2_inv_2 abstract view
.subckt sg13g2_inv_2 Y A VDD VSS
.ends

* Black-box entry subcircuit for sg13g2_nor2_1 abstract view
.subckt sg13g2_nor2_1 Y A B VDD VSS
.ends

* Black-box entry subcircuit for sg13g2_tiehi abstract view
.subckt sg13g2_tiehi L_HI VDD VSS
.ends

* Black-box entry subcircuit for sg13g2_inv_1 abstract view
.subckt sg13g2_inv_1 Y A VDD VSS
.ends

* Black-box entry subcircuit for sg13g2_inv_4 abstract view
.subckt sg13g2_inv_4 Y A VDD VSS
.ends

* Black-box entry subcircuit for sg13g2_nand3b_1 abstract view
.subckt sg13g2_nand3b_1 Y A_N B C VDD VSS
.ends

* Black-box entry subcircuit for sg13g2_tielo abstract view
.subckt sg13g2_tielo L_LO VDD VSS
.ends

* Black-box entry subcircuit for sg13g2_a21o_1 abstract view
.subckt sg13g2_a21o_1 X A1 A2 B1 VDD VSS
.ends

* Black-box entry subcircuit for sg13g2_a21oi_1 abstract view
.subckt sg13g2_a21oi_1 Y A1 A2 B1 VDD VSS
.ends

* Black-box entry subcircuit for sg13g2_nand2b_1 abstract view
.subckt sg13g2_nand2b_1 Y A_N B VDD VSS
.ends

* Black-box entry subcircuit for sg13g2_xor2_1 abstract view
.subckt sg13g2_xor2_1 X A B VDD VSS
.ends

* Black-box entry subcircuit for sg13g2_a22oi_1 abstract view
.subckt sg13g2_a22oi_1 Y A1 A2 B1 B2 VDD VSS
.ends

* Black-box entry subcircuit for sg13g2_nor3_1 abstract view
.subckt sg13g2_nor3_1 Y A B C VDD VSS
.ends

* Black-box entry subcircuit for multimode_dll abstract view
.subckt multimode_dll VDD VSS bias clk0_out clk0_phase_sel[0] clk0_phase_sel[1] clk0_phase_sel[2]
+ clk0_phase_sel[3] clk0_phase_sel[4] clk1_out clk1_phase_sel[0] clk1_phase_sel[1]
+ clk1_phase_sel[2] clk1_phase_sel[3] clk1_phase_sel[4] clk2_out clk2_phase_sel[0]
+ clk2_phase_sel[1] clk2_phase_sel[2] clk2_phase_sel[3] clk2_phase_sel[4] dco enable
+ ext_trim[0] ext_trim[10] ext_trim[11] ext_trim[12] ext_trim[13] ext_trim[14] ext_trim[15]
+ ext_trim[16] ext_trim[17] ext_trim[18] ext_trim[19] ext_trim[1] ext_trim[20] ext_trim[21]
+ ext_trim[22] ext_trim[23] ext_trim[24] ext_trim[25] ext_trim[2] ext_trim[3] ext_trim[4]
+ ext_trim[5] ext_trim[6] ext_trim[7] ext_trim[8] ext_trim[9] f_clk0_divider[0] f_clk0_divider[1]
+ f_clk0_divider[2] f_clk0_divider[3] f_clk0_divider[4] f_clk1_divider[0] f_clk1_divider[1]
+ f_clk1_divider[2] f_clk1_divider[3] f_clk1_divider[4] f_clk2_divider[0] f_clk2_divider[1]
+ f_clk2_divider[2] f_clk2_divider[3] f_clk2_divider[4] f_osc_multiply_factor[0] f_osc_multiply_factor[1]
+ f_osc_multiply_factor[2] f_osc_multiply_factor[3] f_osc_multiply_factor[4] mode_xor[0]
+ mode_xor[1] mode_xor[2] osc osc_out resetb stable
.ends

* Black-box entry subcircuit for SwitchMatrixMultiplexer_inv abstract view
.subckt SwitchMatrixMultiplexer_inv D A VDD B X VSS SEL
.ends

* Black-box entry subcircuit for mux_inv abstract view
.subckt mux_inv X VDD VSS SEL B A
.ends

* Black-box entry subcircuit for latch abstract view
.subckt latch Q D VSS VDD GATE
.ends

* Black-box entry subcircuit for mux abstract view
.subckt mux VSS VDD X A SEL B
.ends

* Black-box entry subcircuit for SwitchMatrixMultiplexer abstract view
.subckt SwitchMatrixMultiplexer D VSS VDD A B X SEL
.ends

.subckt heichips25_internal VGND VPWR analog_pin0 analog_pin1 analog_pin2 clk ena
+ rst_n ui_in[0] ui_in[1] ui_in[2] ui_in[3] ui_in[4] ui_in[5] ui_in[6] ui_in[7] uio_in[0]
+ uio_in[1] uio_in[2] uio_in[3] uio_in[4] uio_in[5] uio_in[6] uio_in[7] uio_oe[0]
+ uio_oe[1] uio_oe[2] uio_oe[3] uio_oe[4] uio_oe[5] uio_oe[6] uio_oe[7] uio_out[0]
+ uio_out[1] uio_out[2] uio_out[3] uio_out[4] uio_out[5] uio_out[6] uio_out[7] uo_out[0]
+ uo_out[1] uo_out[2] uo_out[3] uo_out[4] uo_out[5] uo_out[6] uo_out[7]
XFILLER_11_807 VPWR VGND sg13g2_decap_8
XFILLER_2_538 VPWR VGND sg13g2_fill_1
XFILLER_2_549 VPWR VGND sg13g2_decap_8
X_501_ _501_/Q _685_/CLK _501_/D fanout85/X VPWR VGND sg13g2_dfrbpq_1
X_432_ _597_/D _596_/Q _597_/Q _442_/S VPWR VGND sg13g2_mux2_1
XFILLER_10_884 VPWR VGND sg13g2_decap_8
X_363_ _528_/D _527_/Q _528_/Q _443_/S VPWR VGND sg13g2_mux2_1
X_294_ _671_/D _294_/A _294_/B VPWR VGND sg13g2_nand2_1
XFILLER_6_811 VPWR VGND sg13g2_decap_8
XFILLER_6_888 VPWR VGND sg13g2_decap_8
XFILLER_5_376 VPWR VGND sg13g2_fill_2
XFILLER_5_365 VPWR VGND sg13g2_decap_8
XFILLER_3_1018 VPWR VGND sg13g2_decap_8
XFILLER_45_792 VPWR VGND sg13g2_decap_8
XFILLER_3_836 VPWR VGND sg13g2_decap_8
XFILLER_2_379 VPWR VGND sg13g2_decap_8
XFILLER_2_368 VPWR VGND sg13g2_fill_1
X_415_ _580_/D _579_/Q _580_/Q _419_/S VPWR VGND sg13g2_mux2_1
X_346_ _511_/D _510_/Q _511_/Q _411_/S VPWR VGND sg13g2_mux2_1
X_277_ _277_/X _670_/Q _278_/B VPWR VGND sg13g2_and2_1
XFILLER_0_839 VPWR VGND sg13g2_decap_8
Xclkbuf_5_14__f_clk_regs _677_/CLK clkbuf_4_7_0_clk_regs/X VPWR VGND sg13g2_buf_16
XFILLER_12_968 VPWR VGND sg13g2_decap_8
X_329_ _329_/Y _497_/Q _498_/Q _499_/Q _339_/S VPWR VGND sg13g2_nand4_1
XFILLER_9_55 VPWR VGND sg13g2_fill_1
XFILLER_30_765 VPWR VGND sg13g2_decap_8
XFILLER_9_1024 VPWR VGND sg13g2_decap_4
XFILLER_21_765 VPWR VGND sg13g2_decap_8
XFILLER_0_636 VPWR VGND sg13g2_decap_8
X_680_ _680_/Q _686_/CLK _680_/D fanout78/X VPWR VGND sg13g2_dfrbpq_1
XFILLER_29_821 VPWR VGND sg13g2_decap_8
XFILLER_12_765 VPWR VGND sg13g2_decap_8
XFILLER_4_953 VPWR VGND sg13g2_decap_8
XFILLER_35_813 VPWR VGND sg13g2_decap_8
XFILLER_41_805 VPWR VGND sg13g2_decap_8
XFILLER_5_728 VPWR VGND sg13g2_decap_8
XFILLER_1_967 VPWR VGND sg13g2_decap_8
XFILLER_48_415 VPWR VGND sg13g2_fill_1
X_594_ _594_/Q _596_/CLK _594_/D fanout97/X VPWR VGND sg13g2_dfrbpq_1
X_663_ _663_/Q _477_/Y _663_/D fanout65/X VPWR VGND sg13g2_dfrbpq_1
XFILLER_44_698 VPWR VGND sg13g2_fill_1
XANTENNA_5 ui_in[2] VPWR VGND sg13g2_antennanp
XFILLER_4_750 VPWR VGND sg13g2_decap_8
Xdelaybuf_10_clk delaybuf_11_clk/A delaybuf_9_clk/X VPWR VGND sg13g2_buf_16
XFILLER_14_849 VPWR VGND sg13g2_decap_8
XFILLER_5_514 VPWR VGND sg13g2_decap_8
Xoutput31 uo_out[1] _311_/Y VPWR VGND sg13g2_buf_1
Xoutput20 uio_oe[6] _283_/X VPWR VGND sg13g2_buf_1
XFILLER_5_547 VPWR VGND sg13g2_fill_1
XFILLER_0_274 VPWR VGND sg13g2_fill_1
XFILLER_1_764 VPWR VGND sg13g2_decap_8
XFILLER_49_779 VPWR VGND sg13g2_decap_8
X_577_ _577_/Q _580_/CLK _577_/D fanout95/X VPWR VGND sg13g2_dfrbpq_1
X_646_ _646_/Q _684_/CLK _646_/D fanout76/X VPWR VGND sg13g2_dfrbpq_1
XFILLER_9_842 VPWR VGND sg13g2_decap_8
XFILLER_11_1010 VPWR VGND sg13g2_decap_8
X_500_ _500_/Q _516_/CLK _500_/D fanout87/X VPWR VGND sg13g2_dfrbpq_1
X_431_ _596_/D _595_/Q _596_/Q _431_/S VPWR VGND sg13g2_mux2_1
X_362_ _527_/D _526_/Q _527_/Q _376_/S VPWR VGND sg13g2_mux2_1
XFILLER_10_863 VPWR VGND sg13g2_decap_8
X_293_ _672_/D _632_/Q _294_/A _292_/X VPWR VGND sg13g2_o21ai_1
XFILLER_6_867 VPWR VGND sg13g2_decap_8
XFILLER_5_344 VPWR VGND sg13g2_decap_8
XFILLER_3_68 VPWR VGND sg13g2_fill_2
X_629_ _629_/Q _629_/CLK _629_/D fanout67/X VPWR VGND sg13g2_dfrbpq_1
Xclkbuf_5_13__f_clk_regs _560_/CLK clkbuf_4_6_0_clk_regs/X VPWR VGND sg13g2_buf_16
XFILLER_3_815 VPWR VGND sg13g2_decap_8
X_414_ _579_/D _578_/Q _579_/Q _441_/S VPWR VGND sg13g2_mux2_1
X_345_ _510_/D _509_/Q _510_/Q _411_/S VPWR VGND sg13g2_mux2_1
X_276_ _276_/X _669_/Q _279_/B VPWR VGND sg13g2_and2_1
XFILLER_27_793 VPWR VGND sg13g2_decap_8
XFILLER_2_892 VPWR VGND sg13g2_decap_8
XFILLER_18_793 VPWR VGND sg13g2_decap_8
XFILLER_0_818 VPWR VGND sg13g2_decap_8
XFILLER_12_947 VPWR VGND sg13g2_decap_8
XFILLER_23_54 VPWR VGND sg13g2_fill_2
XFILLER_3_689 VPWR VGND sg13g2_decap_8
X_328_ _498_/D _330_/B _328_/B VPWR VGND sg13g2_and2_1
X_259_ _493_/D _264_/A0 _681_/D _259_/S VPWR VGND sg13g2_mux2_1
XFILLER_9_1003 VPWR VGND sg13g2_decap_8
XFILLER_7_984 VPWR VGND sg13g2_decap_8
XFILLER_0_615 VPWR VGND sg13g2_decap_8
XFILLER_29_800 VPWR VGND sg13g2_decap_8
XFILLER_4_932 VPWR VGND sg13g2_decap_8
XFILLER_7_781 VPWR VGND sg13g2_decap_8
XFILLER_26_814 VPWR VGND sg13g2_decap_8
XFILLER_5_707 VPWR VGND sg13g2_decap_8
XFILLER_0_456 VPWR VGND sg13g2_decap_8
XFILLER_0_467 VPWR VGND sg13g2_fill_1
XFILLER_0_478 VPWR VGND sg13g2_decap_8
XFILLER_17_814 VPWR VGND sg13g2_decap_8
XFILLER_1_946 VPWR VGND sg13g2_decap_8
X_662_ _662_/Q _476_/Y _662_/D fanout73/X VPWR VGND sg13g2_dfrbpq_1
X_593_ _593_/Q _596_/CLK _593_/D fanout97/X VPWR VGND sg13g2_dfrbpq_1
XANTENNA_6 ui_in[5] VPWR VGND sg13g2_antennanp
XFILLER_6_1028 VPWR VGND sg13g2_fill_1
XFILLER_23_828 VPWR VGND sg13g2_decap_8
XFILLER_14_828 VPWR VGND sg13g2_decap_8
XFILLER_1_743 VPWR VGND sg13g2_decap_8
Xdelaybuf_3_clk delaybuf_4_clk/A delaybuf_3_clk/A VPWR VGND sg13g2_buf_16
Xoutput32 uo_out[2] _313_/Y VPWR VGND sg13g2_buf_1
Xoutput21 uio_oe[7] _286_/Y VPWR VGND sg13g2_buf_1
XFILLER_5_559 VPWR VGND sg13g2_decap_8
X_645_ _645_/Q _684_/CLK _645_/D fanout76/X VPWR VGND sg13g2_dfrbpq_1
XFILLER_49_758 VPWR VGND sg13g2_decap_8
X_576_ _576_/Q _576_/CLK _576_/D fanout95/X VPWR VGND sg13g2_dfrbpq_1
XFILLER_9_821 VPWR VGND sg13g2_decap_8
XFILLER_9_898 VPWR VGND sg13g2_decap_8
Xclkbuf_5_12__f_clk_regs _686_/CLK clkbuf_4_6_0_clk_regs/X VPWR VGND sg13g2_buf_16
XFILLER_48_780 VPWR VGND sg13g2_decap_8
X_430_ _595_/D _594_/Q _595_/Q _431_/S VPWR VGND sg13g2_mux2_1
X_361_ _526_/D _525_/Q _526_/Q _439_/S VPWR VGND sg13g2_mux2_1
X_292_ _292_/X _646_/Q _294_/B VPWR VGND sg13g2_or2_1
XFILLER_10_842 VPWR VGND sg13g2_decap_8
XFILLER_6_846 VPWR VGND sg13g2_decap_8
X_628_ _628_/Q _655_/CLK _628_/D fanout67/X VPWR VGND sg13g2_dfrbpq_1
X_559_ _559_/Q _560_/CLK _559_/D fanout78/X VPWR VGND sg13g2_dfrbpq_1
XFILLER_5_890 VPWR VGND sg13g2_decap_8
X_413_ _578_/D _577_/Q _578_/Q _441_/S VPWR VGND sg13g2_mux2_1
XFILLER_27_772 VPWR VGND sg13g2_decap_8
X_344_ _509_/D _508_/Q _509_/Q _407_/S VPWR VGND sg13g2_mux2_1
X_275_ _275_/X _668_/Q _278_/B VPWR VGND sg13g2_and2_1
XFILLER_1_392 VPWR VGND sg13g2_fill_1
XFILLER_2_871 VPWR VGND sg13g2_decap_8
XFILLER_18_772 VPWR VGND sg13g2_decap_8
XFILLER_12_926 VPWR VGND sg13g2_decap_8
XFILLER_8_919 VPWR VGND sg13g2_decap_8
XFILLER_24_786 VPWR VGND sg13g2_decap_8
XFILLER_48_85 VPWR VGND sg13g2_fill_1
XFILLER_47_812 VPWR VGND sg13g2_decap_8
XFILLER_15_786 VPWR VGND sg13g2_decap_8
X_327_ _328_/B _246_/Y _325_/B _332_/A VPWR VGND sg13g2_o21ai_1
X_258_ _494_/D _263_/A0 _682_/D _259_/S VPWR VGND sg13g2_mux2_1
XFILLER_7_963 VPWR VGND sg13g2_decap_8
Xclkbuf_4_9_0_clk_regs clkbuf_4_9_0_clk_regs/X clkbuf_0_clk_regs/X VPWR VGND sg13g2_buf_8
XFILLER_38_834 VPWR VGND sg13g2_fill_1
XFILLER_38_823 VPWR VGND sg13g2_decap_8
XFILLER_44_826 VPWR VGND sg13g2_decap_8
XFILLER_4_911 VPWR VGND sg13g2_decap_8
XFILLER_1_0 VPWR VGND sg13g2_fill_1
XFILLER_4_988 VPWR VGND sg13g2_decap_8
XFILLER_1_925 VPWR VGND sg13g2_decap_8
X_592_ _592_/Q _596_/CLK _592_/D fanout98/X VPWR VGND sg13g2_dfrbpq_1
X_661_ _661_/Q _475_/Y _661_/D fanout74/X VPWR VGND sg13g2_dfrbpq_1
XFILLER_29_54 VPWR VGND sg13g2_fill_2
XFILLER_32_829 VPWR VGND sg13g2_fill_2
XFILLER_32_818 VPWR VGND sg13g2_decap_8
XANTENNA_7 ui_in[5] VPWR VGND sg13g2_antennanp
Xclkbuf_5_11__f_clk_regs _688_/CLK clkbuf_4_5_0_clk_regs/X VPWR VGND sg13g2_buf_16
XFILLER_6_1007 VPWR VGND sg13g2_decap_8
XFILLER_4_785 VPWR VGND sg13g2_decap_8
XFILLER_3_295 VPWR VGND sg13g2_decap_8
XFILLER_23_807 VPWR VGND sg13g2_decap_8
XFILLER_14_807 VPWR VGND sg13g2_decap_8
XFILLER_1_722 VPWR VGND sg13g2_decap_8
XFILLER_1_799 VPWR VGND sg13g2_decap_8
Xoutput33 uo_out[3] _315_/Y VPWR VGND sg13g2_buf_1
Xoutput22 uio_out[0] _270_/X VPWR VGND sg13g2_buf_1
X_575_ _575_/Q _576_/CLK _575_/D fanout95/X VPWR VGND sg13g2_dfrbpq_1
X_644_ _644_/Q _658_/CLK _644_/D fanout70/X VPWR VGND sg13g2_dfrbpq_1
XFILLER_13_884 VPWR VGND sg13g2_decap_8
XFILLER_9_877 VPWR VGND sg13g2_decap_8
XFILLER_9_800 VPWR VGND sg13g2_decap_8
XFILLER_46_729 VPWR VGND sg13g2_fill_1
XFILLER_10_821 VPWR VGND sg13g2_decap_8
X_360_ _525_/D _524_/Q _525_/Q _439_/S VPWR VGND sg13g2_mux2_1
X_291_ _673_/D _250_/Y _294_/A _290_/Y VPWR VGND sg13g2_o21ai_1
XFILLER_10_898 VPWR VGND sg13g2_decap_8
Xclkbuf_4_11_0_clk_regs clkbuf_4_11_0_clk_regs/X clkbuf_0_clk_regs/X VPWR VGND sg13g2_buf_8
XFILLER_6_825 VPWR VGND sg13g2_decap_8
X_627_ _627_/Q _656_/CLK _627_/D fanout65/X VPWR VGND sg13g2_dfrbpq_1
X_558_ _558_/Q _653_/CLK _558_/D fanout73/X VPWR VGND sg13g2_dfrbpq_1
XFILLER_45_740 VPWR VGND sg13g2_fill_1
X_489_ _685_/D _489_/CLK _489_/D fanout75/X VPWR VGND sg13g2_dfrbpq_1
XFILLER_4_390 VPWR VGND sg13g2_decap_8
Xhold140 _649_/D _620_/Q VPWR VGND sg13g2_dlygate4sd3_1
X_412_ _577_/D _576_/Q _577_/Q _441_/S VPWR VGND sg13g2_mux2_1
XFILLER_42_765 VPWR VGND sg13g2_fill_2
X_343_ _508_/D _507_/Q _508_/Q _350_/S VPWR VGND sg13g2_mux2_1
X_274_ _274_/X _667_/Q _278_/B VPWR VGND sg13g2_and2_1
XFILLER_5_165 VPWR VGND sg13g2_fill_2
XFILLER_2_850 VPWR VGND sg13g2_decap_8
XFILLER_49_375 VPWR VGND sg13g2_fill_2
XFILLER_12_905 VPWR VGND sg13g2_decap_8
XFILLER_24_765 VPWR VGND sg13g2_decap_8
XFILLER_2_113 VPWR VGND sg13g2_fill_1
XFILLER_0_27 VPWR VGND sg13g2_fill_2
XFILLER_15_765 VPWR VGND sg13g2_decap_8
X_326_ _330_/B _497_/Q _498_/Q _339_/S VPWR VGND sg13g2_nand3_1
XFILLER_11_982 VPWR VGND sg13g2_decap_8
Xfanout90 fanout90/X fanout93/X VPWR VGND sg13g2_buf_1
X_257_ _495_/D _262_/A0 _683_/D _259_/S VPWR VGND sg13g2_mux2_1
XFILLER_7_942 VPWR VGND sg13g2_decap_8
XFILLER_38_802 VPWR VGND sg13g2_decap_8
XFILLER_21_779 VPWR VGND sg13g2_decap_8
XFILLER_44_805 VPWR VGND sg13g2_decap_8
XFILLER_12_779 VPWR VGND sg13g2_decap_8
Xclkbuf_5_10__f_clk_regs _684_/CLK clkbuf_4_5_0_clk_regs/X VPWR VGND sg13g2_buf_16
XFILLER_4_967 VPWR VGND sg13g2_decap_8
X_309_ _309_/Y _309_/A _307_/B VPWR VGND sg13g2_nor2b_1
Xclkbuf_5_29__f_clk_regs _596_/CLK clkbuf_4_14_0_clk_regs/X VPWR VGND sg13g2_buf_16
Xdelaybuf_22_clk delaybuf_22_clk/X delaybuf_22_clk/A VPWR VGND sg13g2_buf_16
XFILLER_27_0 VPWR VGND sg13g2_fill_1
XFILLER_41_819 VPWR VGND sg13g2_decap_8
XFILLER_0_436 VPWR VGND sg13g2_fill_2
XFILLER_1_904 VPWR VGND sg13g2_decap_8
Xdelaybuf_13_clk delaybuf_14_clk/A delaybuf_13_clk/A VPWR VGND sg13g2_buf_16
X_591_ _591_/Q _591_/CLK _591_/D fanout97/X VPWR VGND sg13g2_dfrbpq_1
X_660_ _660_/Q _474_/Y _660_/D fanout69/X VPWR VGND sg13g2_dfrbpq_1
XANTENNA_8 ui_in[6] VPWR VGND sg13g2_antennanp
XFILLER_4_764 VPWR VGND sg13g2_decap_8
XFILLER_3_252 VPWR VGND sg13g2_decap_8
XFILLER_31_830 VPWR VGND sg13g2_fill_1
XFILLER_1_701 VPWR VGND sg13g2_decap_8
Xoutput34 uo_out[4] _317_/Y VPWR VGND sg13g2_buf_1
Xoutput23 uio_out[1] _271_/X VPWR VGND sg13g2_buf_1
XFILLER_5_528 VPWR VGND sg13g2_decap_8
XFILLER_0_200 VPWR VGND sg13g2_decap_4
XFILLER_1_778 VPWR VGND sg13g2_decap_8
XFILLER_49_716 VPWR VGND sg13g2_fill_2
X_574_ _574_/Q _576_/CLK _574_/D fanout94/X VPWR VGND sg13g2_dfrbpq_1
X_643_ _643_/Q _658_/CLK _643_/D fanout67/X VPWR VGND sg13g2_dfrbpq_1
XFILLER_13_863 VPWR VGND sg13g2_decap_8
XFILLER_9_856 VPWR VGND sg13g2_decap_8
XFILLER_11_1024 VPWR VGND sg13g2_decap_4
XFILLER_10_800 VPWR VGND sg13g2_decap_8
XFILLER_10_877 VPWR VGND sg13g2_decap_8
X_290_ _290_/Y _303_/S _645_/Q _646_/Q VPWR VGND sg13g2_nand3_1
XFILLER_6_804 VPWR VGND sg13g2_decap_8
XFILLER_5_358 VPWR VGND sg13g2_decap_8
X_626_ _626_/Q _655_/CLK _626_/D fanout65/X VPWR VGND sg13g2_dfrbpq_1
X_557_ _557_/Q _654_/CLK _557_/D fanout73/X VPWR VGND sg13g2_dfrbpq_1
X_488_ _488_/Y _488_/A _488_/B VPWR VGND sg13g2_xnor2_1
XFILLER_45_785 VPWR VGND sg13g2_decap_8
Xhold141 _641_/D _614_/Q VPWR VGND sg13g2_dlygate4sd3_1
XFILLER_3_829 VPWR VGND sg13g2_decap_8
XFILLER_2_317 VPWR VGND sg13g2_fill_2
XFILLER_2_1011 VPWR VGND sg13g2_decap_8
X_411_ _576_/D _575_/Q _576_/Q _411_/S VPWR VGND sg13g2_mux2_1
X_342_ _507_/D _506_/Q _507_/Q _397_/S VPWR VGND sg13g2_mux2_1
X_273_ _273_/X _666_/Q _278_/B VPWR VGND sg13g2_and2_1
X_609_ _636_/D _649_/CLK _609_/D fanout81/X VPWR VGND sg13g2_dfrbpq_1
XFILLER_45_571 VPWR VGND sg13g2_fill_1
XFILLER_3_659 VPWR VGND sg13g2_decap_4
XFILLER_11_961 VPWR VGND sg13g2_decap_8
Xfanout80 fanout80/X fanout99/A VPWR VGND sg13g2_buf_1
Xfanout91 fanout91/X fanout93/X VPWR VGND sg13g2_buf_1
X_325_ _497_/D _497_/Q _325_/B VPWR VGND sg13g2_xnor2_1
X_256_ _496_/D _261_/A0 _684_/D _259_/S VPWR VGND sg13g2_mux2_1
XFILLER_7_998 VPWR VGND sg13g2_decap_4
XFILLER_7_921 VPWR VGND sg13g2_decap_8
Xclkbuf_5_28__f_clk_regs _591_/CLK clkbuf_4_14_0_clk_regs/X VPWR VGND sg13g2_buf_16
Xclkbuf_leaf_1_clk _284_/B clkload0/A VPWR VGND sg13g2_buf_8
XFILLER_9_1028 VPWR VGND sg13g2_fill_1
XFILLER_9_1017 VPWR VGND sg13g2_decap_8
XFILLER_0_629 VPWR VGND sg13g2_decap_8
Xu_delay_line VPWR VGND u_delay_line/clk _488_/A fanout99/X u_delay_line/sel[0] u_delay_line/sel[1]
+ u_delay_line/sel[2] u_delay_line/sel[3] u_delay_line/trim[0] u_delay_line_115/L_HI
+ u_delay_line_116/L_HI u_delay_line_117/L_HI u_delay_line_118/L_HI u_delay_line_119/L_HI
+ u_delay_line_120/L_HI u_delay_line_121/L_HI u_delay_line_122/L_HI u_delay_line_123/L_HI
+ u_delay_line_124/L_HI u_delay_line/trim[1] u_delay_line_125/L_HI u_delay_line_126/L_HI
+ u_delay_line_127/L_HI u_delay_line_128/L_HI u_delay_line/trim[2] u_delay_line/trim[3]
+ u_delay_line/trim[4] u_delay_line/trim[5] u_delay_line/trim[6] u_delay_line/trim[7]
+ u_delay_line/trim[8] u_delay_line/trim[9] delay_line
XFILLER_29_814 VPWR VGND sg13g2_decap_8
Xclkload0 clkload0/X clkload0/A VPWR VGND sg13g2_buf_8
XFILLER_4_946 VPWR VGND sg13g2_decap_8
XFILLER_35_806 VPWR VGND sg13g2_decap_8
X_308_ _308_/X _308_/A0 _308_/A1 _488_/A _677_/Q _307_/B _309_/A VPWR VGND sg13g2_mux4_1
XFILLER_7_795 VPWR VGND sg13g2_decap_8
XFILLER_3_990 VPWR VGND sg13g2_decap_8
XFILLER_26_828 VPWR VGND sg13g2_fill_2
XFILLER_20_47 VPWR VGND sg13g2_fill_1
XFILLER_17_828 VPWR VGND sg13g2_decap_8
X_590_ _590_/Q _591_/CLK _590_/D fanout97/X VPWR VGND sg13g2_dfrbpq_1
XANTENNA_9 ui_in[7] VPWR VGND sg13g2_antennanp
Xdelaybuf_6_clk delaybuf_7_clk/A delaybuf_6_clk/A VPWR VGND sg13g2_buf_16
XFILLER_4_743 VPWR VGND sg13g2_decap_8
XFILLER_3_286 VPWR VGND sg13g2_fill_1
XFILLER_0_993 VPWR VGND sg13g2_decap_8
Xoutput35 uo_out[5] _267_/X VPWR VGND sg13g2_buf_1
Xoutput24 uio_out[2] _272_/X VPWR VGND sg13g2_buf_1
XFILLER_1_757 VPWR VGND sg13g2_decap_8
X_642_ _642_/Q _651_/CLK _642_/D fanout65/X VPWR VGND sg13g2_dfrbpq_1
XFILLER_13_842 VPWR VGND sg13g2_decap_8
X_573_ _573_/Q _573_/CLK _573_/D fanout94/X VPWR VGND sg13g2_dfrbpq_1
XFILLER_9_835 VPWR VGND sg13g2_decap_8
XFILLER_0_790 VPWR VGND sg13g2_decap_8
XFILLER_48_794 VPWR VGND sg13g2_decap_8
XFILLER_11_1003 VPWR VGND sg13g2_decap_8
XFILLER_39_772 VPWR VGND sg13g2_fill_1
XFILLER_10_856 VPWR VGND sg13g2_decap_8
XFILLER_1_587 VPWR VGND sg13g2_fill_2
X_625_ _654_/D _654_/CLK _625_/D fanout73/X VPWR VGND sg13g2_dfrbpq_1
X_556_ _556_/Q _654_/CLK _556_/D fanout68/X VPWR VGND sg13g2_dfrbpq_1
X_487_ _487_/Y _488_/A _487_/B VPWR VGND sg13g2_xnor2_1
Xhold142 _633_/D _606_/Q VPWR VGND sg13g2_dlygate4sd3_1
Xhold131 _677_/D _685_/Q VPWR VGND sg13g2_dlygate4sd3_1
XFILLER_3_808 VPWR VGND sg13g2_decap_8
X_410_ _575_/D _574_/Q _575_/Q _411_/S VPWR VGND sg13g2_mux2_1
X_341_ _506_/D _505_/Q _506_/Q _397_/S VPWR VGND sg13g2_mux2_1
X_272_ _272_/X _665_/Q _278_/B VPWR VGND sg13g2_and2_1
XFILLER_27_786 VPWR VGND sg13g2_decap_8
Xclkbuf_5_27__f_clk_regs _573_/CLK clkbuf_4_13_0_clk_regs/X VPWR VGND sg13g2_buf_16
XFILLER_2_885 VPWR VGND sg13g2_decap_8
XFILLER_18_786 VPWR VGND sg13g2_decap_8
X_608_ _635_/D _648_/CLK _608_/D fanout84/X VPWR VGND sg13g2_dfrbpq_1
XFILLER_14_981 VPWR VGND sg13g2_decap_8
X_539_ _539_/Q _539_/CLK _539_/D fanout84/X VPWR VGND sg13g2_dfrbpq_1
XFILLER_3_627 VPWR VGND sg13g2_decap_4
XFILLER_47_826 VPWR VGND sg13g2_fill_1
XFILLER_11_940 VPWR VGND sg13g2_decap_8
Xfanout70 fanout70/X fanout72/X VPWR VGND sg13g2_buf_1
Xfanout81 fanout81/X fanout82/X VPWR VGND sg13g2_buf_1
Xfanout92 fanout92/X fanout93/X VPWR VGND sg13g2_buf_1
X_324_ _325_/B _323_/A _323_/B _339_/S VPWR VGND sg13g2_o21ai_1
X_255_ _259_/S _676_/Q _675_/Q VPWR VGND sg13g2_nand2_1
XFILLER_7_900 VPWR VGND sg13g2_decap_8
XFILLER_7_977 VPWR VGND sg13g2_decap_8
XFILLER_1_170 VPWR VGND sg13g2_fill_2
XFILLER_2_682 VPWR VGND sg13g2_decap_8
XFILLER_0_608 VPWR VGND sg13g2_decap_8
Xclkload1 clkload1/Y _483_/B VPWR VGND sg13g2_inv_2
XFILLER_4_925 VPWR VGND sg13g2_decap_8
X_307_ _307_/Y _309_/A _307_/B VPWR VGND sg13g2_nor2_1
XFILLER_26_807 VPWR VGND sg13g2_decap_8
XFILLER_0_438 VPWR VGND sg13g2_fill_1
XFILLER_0_449 VPWR VGND sg13g2_decap_8
XFILLER_1_939 VPWR VGND sg13g2_decap_8
XFILLER_17_807 VPWR VGND sg13g2_decap_8
Xclkbuf_4_8_0_clk_regs clkbuf_4_8_0_clk_regs/X clkbuf_0_clk_regs/X VPWR VGND sg13g2_buf_8
Xu_delay_line_120 u_delay_line_120/L_HI VPWR VGND sg13g2_tiehi
XFILLER_40_832 VPWR VGND sg13g2_fill_2
XFILLER_4_799 VPWR VGND sg13g2_decap_8
XFILLER_4_722 VPWR VGND sg13g2_decap_8
XFILLER_0_972 VPWR VGND sg13g2_decap_8
XFILLER_32_0 VPWR VGND sg13g2_fill_1
XFILLER_22_821 VPWR VGND sg13g2_decap_8
XFILLER_1_736 VPWR VGND sg13g2_decap_8
Xoutput36 uo_out[6] _268_/X VPWR VGND sg13g2_buf_1
Xoutput25 uio_out[3] _273_/X VPWR VGND sg13g2_buf_1
Xoutput14 uio_oe[0] _277_/X VPWR VGND sg13g2_buf_1
X_641_ _641_/Q _651_/CLK _641_/D fanout65/X VPWR VGND sg13g2_dfrbpq_1
X_572_ _572_/Q _573_/CLK _572_/D fanout94/X VPWR VGND sg13g2_dfrbpq_1
XFILLER_49_718 VPWR VGND sg13g2_fill_1
XFILLER_13_821 VPWR VGND sg13g2_decap_8
XFILLER_9_814 VPWR VGND sg13g2_decap_8
XFILLER_44_489 VPWR VGND sg13g2_fill_1
XFILLER_13_898 VPWR VGND sg13g2_decap_8
XFILLER_48_773 VPWR VGND sg13g2_decap_8
XFILLER_8_891 VPWR VGND sg13g2_decap_8
XFILLER_10_835 VPWR VGND sg13g2_decap_8
XFILLER_6_839 VPWR VGND sg13g2_decap_8
Xclkbuf_5_26__f_clk_regs _570_/CLK clkbuf_4_13_0_clk_regs/X VPWR VGND sg13g2_buf_16
X_624_ _653_/D _652_/CLK _624_/D fanout68/X VPWR VGND sg13g2_dfrbpq_1
X_555_ _555_/Q _654_/CLK _555_/D fanout68/X VPWR VGND sg13g2_dfrbpq_1
X_486_ _486_/Y _488_/A _488_/B VPWR VGND sg13g2_xnor2_1
XFILLER_5_883 VPWR VGND sg13g2_decap_8
XFILLER_12_27 VPWR VGND sg13g2_fill_2
Xhold143 _656_/D _627_/Q VPWR VGND sg13g2_dlygate4sd3_1
Xhold132 _658_/D _629_/Q VPWR VGND sg13g2_dlygate4sd3_1
XFILLER_2_319 VPWR VGND sg13g2_fill_1
XFILLER_27_765 VPWR VGND sg13g2_decap_8
X_340_ _505_/D _504_/Q _505_/Q _397_/S VPWR VGND sg13g2_mux2_1
X_271_ _271_/X _664_/Q _278_/B VPWR VGND sg13g2_and2_1
XFILLER_2_864 VPWR VGND sg13g2_decap_8
XFILLER_18_765 VPWR VGND sg13g2_decap_8
X_607_ _634_/D _607_/CLK _607_/D fanout93/X VPWR VGND sg13g2_dfrbpq_1
X_538_ _538_/Q _648_/CLK _538_/D fanout82/X VPWR VGND sg13g2_dfrbpq_1
X_469_ _469_/Y _488_/A _472_/B VPWR VGND sg13g2_xnor2_1
XFILLER_12_919 VPWR VGND sg13g2_decap_8
Xclkbuf_4_10_0_clk_regs clkbuf_4_10_0_clk_regs/X clkbuf_0_clk_regs/X VPWR VGND sg13g2_buf_8
XFILLER_32_790 VPWR VGND sg13g2_decap_8
XFILLER_24_779 VPWR VGND sg13g2_decap_8
XFILLER_47_805 VPWR VGND sg13g2_decap_8
XFILLER_15_779 VPWR VGND sg13g2_decap_8
XFILLER_11_996 VPWR VGND sg13g2_decap_8
Xfanout60 _419_/S _433_/S VPWR VGND sg13g2_buf_1
Xfanout71 fanout71/X fanout72/X VPWR VGND sg13g2_buf_1
Xfanout82 fanout82/X fanout89/X VPWR VGND sg13g2_buf_1
Xfanout93 fanout93/X fanout99/A VPWR VGND sg13g2_buf_1
X_323_ _323_/Y _323_/A _323_/B VPWR VGND sg13g2_nor2_1
X_254_ _254_/Y _681_/Q VPWR VGND sg13g2_inv_1
XFILLER_7_956 VPWR VGND sg13g2_decap_8
XFILLER_2_661 VPWR VGND sg13g2_decap_8
XFILLER_38_816 VPWR VGND sg13g2_decap_8
Xdelaybuf_25_clk delaybuf_26_clk/A delaybuf_25_clk/A VPWR VGND sg13g2_buf_16
XFILLER_44_819 VPWR VGND sg13g2_decap_8
XFILLER_20_793 VPWR VGND sg13g2_decap_8
Xclkload2 clkload2/Y _478_/B VPWR VGND sg13g2_inv_4
Xdelaybuf_16_clk delaybuf_17_clk/A clkbuf_0_clk/X VPWR VGND sg13g2_buf_16
XFILLER_4_904 VPWR VGND sg13g2_decap_8
X_306_ _662_/D _640_/Q _654_/Q _306_/S VPWR VGND sg13g2_mux2_1
XFILLER_11_793 VPWR VGND sg13g2_decap_8
XFILLER_14_1002 VPWR VGND sg13g2_decap_8
XFILLER_1_918 VPWR VGND sg13g2_decap_8
XFILLER_40_811 VPWR VGND sg13g2_decap_8
Xu_delay_line_121 u_delay_line_121/L_HI VPWR VGND sg13g2_tiehi
Xu_delay_line_110 u_delay_line/trim[5] VPWR VGND sg13g2_tiehi
XFILLER_4_701 VPWR VGND sg13g2_decap_8
XFILLER_0_951 VPWR VGND sg13g2_decap_8
XFILLER_4_778 VPWR VGND sg13g2_decap_8
XFILLER_22_800 VPWR VGND sg13g2_decap_8
Xclkbuf_5_25__f_clk_regs _576_/CLK clkbuf_4_12_0_clk_regs/X VPWR VGND sg13g2_buf_16
XFILLER_1_715 VPWR VGND sg13g2_decap_8
Xoutput37 uo_out[7] _269_/X VPWR VGND sg13g2_buf_1
Xoutput26 uio_out[4] _279_/B VPWR VGND sg13g2_buf_1
Xoutput15 uio_oe[1] _278_/X VPWR VGND sg13g2_buf_1
X_640_ _640_/Q _654_/CLK _640_/D fanout73/X VPWR VGND sg13g2_dfrbpq_1
X_571_ _571_/Q _573_/CLK _571_/D fanout88/X VPWR VGND sg13g2_dfrbpq_1
XFILLER_13_800 VPWR VGND sg13g2_decap_8
XFILLER_13_877 VPWR VGND sg13g2_decap_8
XFILLER_48_752 VPWR VGND sg13g2_decap_8
XFILLER_8_870 VPWR VGND sg13g2_decap_8
XFILLER_10_814 VPWR VGND sg13g2_decap_8
Xclkbuf_5_9__f_clk_regs _653_/CLK clkbuf_4_4_0_clk_regs/X VPWR VGND sg13g2_buf_16
XFILLER_1_501 VPWR VGND sg13g2_fill_2
XFILLER_6_818 VPWR VGND sg13g2_decap_8
XFILLER_1_589 VPWR VGND sg13g2_fill_1
X_623_ _652_/D _629_/CLK _623_/D fanout66/X VPWR VGND sg13g2_dfrbpq_1
X_554_ _554_/Q _652_/CLK _554_/D fanout68/X VPWR VGND sg13g2_dfrbpq_1
X_485_ _485_/Y _488_/A _488_/B VPWR VGND sg13g2_xnor2_1
XFILLER_45_799 VPWR VGND sg13g2_decap_8
XFILLER_5_862 VPWR VGND sg13g2_decap_8
XFILLER_36_799 VPWR VGND sg13g2_decap_8
Xhold144 _639_/D _612_/Q VPWR VGND sg13g2_dlygate4sd3_1
Xhold133 _678_/D _686_/Q VPWR VGND sg13g2_dlygate4sd3_1
XFILLER_2_1025 VPWR VGND sg13g2_decap_4
X_270_ _270_/X _663_/Q _278_/B VPWR VGND sg13g2_and2_1
XFILLER_2_843 VPWR VGND sg13g2_decap_8
XFILLER_14_950 VPWR VGND sg13g2_decap_8
XFILLER_14_961 VPWR VGND sg13g2_fill_1
X_606_ _606_/Q _607_/CLK _606_/D fanout92/X VPWR VGND sg13g2_dfrbpq_1
X_537_ _537_/Q _542_/CLK _537_/D fanout81/X VPWR VGND sg13g2_dfrbpq_1
X_468_ _468_/Y _488_/A _468_/B VPWR VGND sg13g2_xnor2_1
X_399_ _564_/D _563_/Q _564_/Q _457_/S VPWR VGND sg13g2_mux2_1
XFILLER_41_791 VPWR VGND sg13g2_decap_8
Xclkbuf_leaf_4_clk _483_/B clkbuf_leaf_6_clk/A VPWR VGND sg13g2_buf_8
XFILLER_2_128 VPWR VGND sg13g2_fill_1
X_322_ _323_/B _497_/Q _499_/Q _500_/Q _503_/Q VPWR VGND sg13g2_nand4_1
XFILLER_11_975 VPWR VGND sg13g2_decap_8
Xfanout50 fanout50/X _319_/Y VPWR VGND sg13g2_buf_1
Xfanout61 _433_/S _319_/Y VPWR VGND sg13g2_buf_1
Xfanout72 fanout72/X fanout99/A VPWR VGND sg13g2_buf_1
Xfanout83 fanout83/X fanout89/X VPWR VGND sg13g2_buf_1
Xfanout94 fanout94/X fanout95/X VPWR VGND sg13g2_buf_1
X_253_ _253_/Y _680_/Q VPWR VGND sg13g2_inv_1
XFILLER_7_935 VPWR VGND sg13g2_decap_8
XFILLER_2_640 VPWR VGND sg13g2_decap_8
XFILLER_18_27 VPWR VGND sg13g2_fill_2
XFILLER_29_828 VPWR VGND sg13g2_decap_8
XFILLER_20_772 VPWR VGND sg13g2_decap_8
Xclkload3 clkload3/Y _468_/B VPWR VGND sg13g2_inv_2
Xdelaybuf_9_clk delaybuf_9_clk/X delaybuf_9_clk/A VPWR VGND sg13g2_buf_16
X_305_ _661_/D _639_/Q _653_/Q _306_/S VPWR VGND sg13g2_mux2_1
XFILLER_11_772 VPWR VGND sg13g2_decap_8
XFILLER_7_765 VPWR VGND sg13g2_decap_4
Xclkbuf_5_24__f_clk_regs _516_/CLK clkbuf_4_12_0_clk_regs/X VPWR VGND sg13g2_buf_16
XFILLER_0_429 VPWR VGND sg13g2_decap_8
XFILLER_29_15 VPWR VGND sg13g2_fill_2
Xu_delay_line_122 u_delay_line_122/L_HI VPWR VGND sg13g2_tiehi
Xu_delay_line_111 u_delay_line/trim[6] VPWR VGND sg13g2_tiehi
XFILLER_40_834 VPWR VGND sg13g2_fill_1
XFILLER_4_757 VPWR VGND sg13g2_decap_8
XFILLER_3_245 VPWR VGND sg13g2_decap_8
XFILLER_0_930 VPWR VGND sg13g2_decap_8
XFILLER_31_823 VPWR VGND sg13g2_decap_8
Xclkbuf_5_8__f_clk_regs _654_/CLK clkbuf_4_4_0_clk_regs/X VPWR VGND sg13g2_buf_16
XFILLER_0_204 VPWR VGND sg13g2_fill_1
XFILLER_0_215 VPWR VGND sg13g2_fill_1
XFILLER_0_226 VPWR VGND sg13g2_decap_8
Xoutput27 uio_out[5] _274_/X VPWR VGND sg13g2_buf_1
Xoutput16 uio_oe[2] _279_/X VPWR VGND sg13g2_buf_1
XFILLER_5_1023 VPWR VGND sg13g2_decap_4
X_570_ _570_/Q _570_/CLK _570_/D fanout88/X VPWR VGND sg13g2_dfrbpq_1
XFILLER_13_856 VPWR VGND sg13g2_decap_8
XFILLER_9_849 VPWR VGND sg13g2_decap_8
Xclkbuf_0_clk clkbuf_0_clk/X clk VPWR VGND sg13g2_buf_16
XFILLER_11_1017 VPWR VGND sg13g2_decap_8
XFILLER_11_1028 VPWR VGND sg13g2_fill_1
XFILLER_26_27 VPWR VGND sg13g2_fill_2
XFILLER_1_557 VPWR VGND sg13g2_fill_2
X_622_ _651_/D _650_/CLK _622_/D fanout71/X VPWR VGND sg13g2_dfrbpq_1
X_553_ _553_/Q _629_/CLK _553_/D fanout68/X VPWR VGND sg13g2_dfrbpq_1
X_484_ _484_/Y _488_/A _484_/B VPWR VGND sg13g2_xnor2_1
XFILLER_45_778 VPWR VGND sg13g2_decap_8
XFILLER_5_841 VPWR VGND sg13g2_decap_8
Xhold145 _650_/D _621_/Q VPWR VGND sg13g2_dlygate4sd3_1
Xhold134 _657_/D _628_/Q VPWR VGND sg13g2_dlygate4sd3_1
XFILLER_2_1004 VPWR VGND sg13g2_decap_8
XFILLER_5_137 VPWR VGND sg13g2_fill_1
XFILLER_2_899 VPWR VGND sg13g2_decap_8
XFILLER_2_822 VPWR VGND sg13g2_decap_8
X_605_ _605_/Q _607_/CLK _605_/D fanout92/X VPWR VGND sg13g2_dfrbpq_1
XFILLER_14_995 VPWR VGND sg13g2_decap_8
X_536_ _536_/Q _649_/CLK _536_/D fanout81/X VPWR VGND sg13g2_dfrbpq_1
X_467_ _467_/Y _488_/A _468_/B VPWR VGND sg13g2_xnor2_1
X_398_ _563_/D _562_/Q _563_/Q _398_/S VPWR VGND sg13g2_mux2_1
XFILLER_4_192 VPWR VGND sg13g2_fill_2
Xfanout40 _463_/S _464_/S VPWR VGND sg13g2_buf_1
Xfanout51 _443_/S _376_/S VPWR VGND sg13g2_buf_1
Xfanout62 _278_/B _279_/B VPWR VGND sg13g2_buf_1
Xfanout73 fanout73/X fanout80/X VPWR VGND sg13g2_buf_1
X_321_ _323_/A _498_/Q _501_/Q _502_/Q VPWR VGND sg13g2_nand3b_1
X_252_ _252_/Y _679_/Q VPWR VGND sg13g2_inv_1
XFILLER_11_954 VPWR VGND sg13g2_decap_8
Xfanout84 fanout84/X fanout89/X VPWR VGND sg13g2_buf_1
Xfanout95 fanout95/X fanout96/X VPWR VGND sg13g2_buf_1
XFILLER_7_914 VPWR VGND sg13g2_decap_8
XFILLER_2_696 VPWR VGND sg13g2_decap_8
Xclkbuf_5_23__f_clk_regs _633_/CLK clkbuf_4_11_0_clk_regs/X VPWR VGND sg13g2_buf_16
Xclkload10 clkload10/Y _560_/CLK VPWR VGND sg13g2_inv_1
X_519_ _519_/Q _525_/CLK _519_/D fanout90/X VPWR VGND sg13g2_dfrbpq_1
XFILLER_48_0 VPWR VGND sg13g2_fill_1
XFILLER_29_807 VPWR VGND sg13g2_decap_8
Xclkload4 clkload4/Y _658_/CLK VPWR VGND sg13g2_inv_1
XFILLER_4_939 VPWR VGND sg13g2_decap_8
XFILLER_8_1010 VPWR VGND sg13g2_decap_8
X_304_ _660_/D _638_/Q _652_/Q _306_/S VPWR VGND sg13g2_mux2_1
XFILLER_7_788 VPWR VGND sg13g2_decap_8
XFILLER_3_983 VPWR VGND sg13g2_decap_8
Xclkbuf_5_7__f_clk_regs _649_/CLK clkbuf_4_3_0_clk_regs/X VPWR VGND sg13g2_buf_16
XFILLER_2_493 VPWR VGND sg13g2_fill_1
XFILLER_34_810 VPWR VGND sg13g2_decap_8
XFILLER_25_821 VPWR VGND sg13g2_decap_8
Xu_delay_line_123 u_delay_line_123/L_HI VPWR VGND sg13g2_tiehi
Xu_delay_line_112 u_delay_line/trim[7] VPWR VGND sg13g2_tiehi
Xu_delay_line_101 u_delay_line/sel[0] VPWR VGND sg13g2_tielo
XFILLER_4_736 VPWR VGND sg13g2_decap_8
XFILLER_0_986 VPWR VGND sg13g2_decap_8
Xclkbuf_regs_0_clk clkbuf_regs_0_clk/X delaybuf_28_clk/X VPWR VGND sg13g2_buf_16
XFILLER_16_821 VPWR VGND sg13g2_decap_8
XFILLER_31_802 VPWR VGND sg13g2_decap_8
XFILLER_3_780 VPWR VGND sg13g2_decap_8
Xoutput28 uio_out[6] _275_/X VPWR VGND sg13g2_buf_1
Xoutput17 uio_oe[3] _280_/X VPWR VGND sg13g2_buf_1
XFILLER_5_1002 VPWR VGND sg13g2_decap_8
XFILLER_13_835 VPWR VGND sg13g2_decap_8
XFILLER_9_828 VPWR VGND sg13g2_decap_8
XFILLER_0_783 VPWR VGND sg13g2_decap_8
XFILLER_48_787 VPWR VGND sg13g2_decap_8
Xclkbuf_4_7_0_clk_regs clkbuf_4_7_0_clk_regs/X clkbuf_0_clk_regs/X VPWR VGND sg13g2_buf_8
XFILLER_10_849 VPWR VGND sg13g2_decap_8
X_621_ _621_/Q _650_/CLK _621_/D fanout70/X VPWR VGND sg13g2_dfrbpq_1
X_552_ _552_/Q _651_/CLK _552_/D fanout66/X VPWR VGND sg13g2_dfrbpq_1
X_483_ _483_/Y _488_/A _483_/B VPWR VGND sg13g2_xnor2_1
XFILLER_5_820 VPWR VGND sg13g2_decap_8
XFILLER_4_341 VPWR VGND sg13g2_fill_2
XFILLER_5_897 VPWR VGND sg13g2_decap_8
Xhold146 _644_/D _617_/Q VPWR VGND sg13g2_dlygate4sd3_1
Xhold135 _680_/D _688_/Q VPWR VGND sg13g2_dlygate4sd3_1
XFILLER_37_27 VPWR VGND sg13g2_fill_2
XFILLER_27_779 VPWR VGND sg13g2_decap_8
XFILLER_1_388 VPWR VGND sg13g2_decap_4
XFILLER_2_878 VPWR VGND sg13g2_decap_8
XFILLER_2_801 VPWR VGND sg13g2_decap_8
XFILLER_18_779 VPWR VGND sg13g2_decap_8
X_604_ _604_/Q _607_/CLK _604_/D fanout92/X VPWR VGND sg13g2_dfrbpq_1
X_535_ _535_/Q _650_/CLK _535_/D fanout81/X VPWR VGND sg13g2_dfrbpq_1
XFILLER_14_974 VPWR VGND sg13g2_decap_8
Xclkbuf_5_22__f_clk_regs _525_/CLK clkbuf_4_11_0_clk_regs/X VPWR VGND sg13g2_buf_16
X_466_ _466_/Y _488_/A _468_/B VPWR VGND sg13g2_xnor2_1
X_397_ _562_/D _561_/Q _562_/Q _397_/S VPWR VGND sg13g2_mux2_1
XFILLER_5_650 VPWR VGND sg13g2_decap_8
XFILLER_4_97 VPWR VGND sg13g2_fill_1
XFILLER_4_86 VPWR VGND sg13g2_fill_2
Xdelaybuf_28_clk delaybuf_28_clk/X delaybuf_28_clk/A VPWR VGND sg13g2_buf_16
XFILLER_47_819 VPWR VGND sg13g2_decap_8
XFILLER_11_933 VPWR VGND sg13g2_decap_8
Xfanout41 _464_/S _457_/S VPWR VGND sg13g2_buf_1
Xfanout52 _376_/S _441_/S VPWR VGND sg13g2_buf_1
Xfanout63 _279_/B _282_/B VPWR VGND sg13g2_buf_1
Xfanout74 fanout74/X fanout80/X VPWR VGND sg13g2_buf_1
Xfanout85 fanout85/X fanout89/X VPWR VGND sg13g2_buf_1
Xfanout96 fanout96/X fanout99/A VPWR VGND sg13g2_buf_1
X_320_ _335_/A _501_/Q _502_/Q VPWR VGND sg13g2_and2_1
X_251_ _251_/Y _678_/Q VPWR VGND sg13g2_inv_1
XFILLER_23_793 VPWR VGND sg13g2_decap_8
Xdelaybuf_19_clk delaybuf_20_clk/A delaybuf_19_clk/A VPWR VGND sg13g2_buf_16
XFILLER_8_0 VPWR VGND sg13g2_fill_2
Xclkbuf_5_6__f_clk_regs _650_/CLK clkbuf_4_3_0_clk_regs/X VPWR VGND sg13g2_buf_16
XFILLER_2_675 VPWR VGND sg13g2_decap_8
X_518_ _518_/Q _525_/CLK _518_/D fanout90/X VPWR VGND sg13g2_dfrbpq_1
XFILLER_46_830 VPWR VGND sg13g2_fill_1
XFILLER_14_793 VPWR VGND sg13g2_decap_8
Xclkload11 clkload11/Y _648_/CLK VPWR VGND sg13g2_inv_1
X_449_ _614_/D _640_/D _614_/Q _463_/S VPWR VGND sg13g2_mux2_1
Xclkload5 clkload5/Y _652_/CLK VPWR VGND sg13g2_inv_1
XFILLER_4_918 VPWR VGND sg13g2_decap_8
X_303_ _659_/D _637_/Q _651_/Q _303_/S VPWR VGND sg13g2_mux2_1
XFILLER_3_962 VPWR VGND sg13g2_decap_8
XFILLER_2_472 VPWR VGND sg13g2_decap_8
XFILLER_14_1027 VPWR VGND sg13g2_fill_2
Xclkbuf_0__017__regs clkbuf_0__017__regs/X clkbuf_regs_1_clk/X VPWR VGND sg13g2_buf_16
XFILLER_25_800 VPWR VGND sg13g2_decap_8
Xu_delay_line_124 u_delay_line_124/L_HI VPWR VGND sg13g2_tiehi
Xu_delay_line_113 u_delay_line/trim[8] VPWR VGND sg13g2_tiehi
Xu_delay_line_102 u_delay_line/sel[1] VPWR VGND sg13g2_tielo
XFILLER_40_825 VPWR VGND sg13g2_decap_8
XFILLER_4_715 VPWR VGND sg13g2_decap_8
XFILLER_0_965 VPWR VGND sg13g2_decap_8
XFILLER_16_800 VPWR VGND sg13g2_decap_8
XFILLER_22_814 VPWR VGND sg13g2_decap_8
XFILLER_1_729 VPWR VGND sg13g2_decap_8
Xoutput29 uio_out[7] _276_/X VPWR VGND sg13g2_buf_1
Xoutput18 uio_oe[4] _281_/X VPWR VGND sg13g2_buf_1
XFILLER_13_814 VPWR VGND sg13g2_decap_8
XFILLER_9_807 VPWR VGND sg13g2_decap_8
XFILLER_0_762 VPWR VGND sg13g2_decap_8
XFILLER_4_556 VPWR VGND sg13g2_fill_1
XFILLER_48_766 VPWR VGND sg13g2_decap_8
XFILLER_12_891 VPWR VGND sg13g2_decap_8
XFILLER_7_20 VPWR VGND sg13g2_fill_1
XFILLER_8_884 VPWR VGND sg13g2_decap_8
XFILLER_10_828 VPWR VGND sg13g2_decap_8
XFILLER_1_559 VPWR VGND sg13g2_fill_1
X_620_ _620_/Q _648_/CLK _620_/D fanout82/X VPWR VGND sg13g2_dfrbpq_1
X_551_ _551_/Q _651_/CLK _551_/D fanout66/X VPWR VGND sg13g2_dfrbpq_1
Xclkbuf_5_21__f_clk_regs _601_/CLK clkbuf_4_10_0_clk_regs/X VPWR VGND sg13g2_buf_16
X_482_ _482_/Y _488_/A _483_/B VPWR VGND sg13g2_xnor2_1
XFILLER_5_876 VPWR VGND sg13g2_decap_8
XFILLER_4_397 VPWR VGND sg13g2_decap_8
XFILLER_44_791 VPWR VGND sg13g2_decap_8
Xhold147 _643_/D _616_/Q VPWR VGND sg13g2_dlygate4sd3_1
Xhold136 _648_/D _619_/Q VPWR VGND sg13g2_dlygate4sd3_1
XFILLER_1_345 VPWR VGND sg13g2_decap_4
Xclkbuf_5_5__f_clk_regs _656_/CLK clkbuf_4_2_0_clk_regs/X VPWR VGND sg13g2_buf_16
XFILLER_2_857 VPWR VGND sg13g2_decap_8
XFILLER_14_920 VPWR VGND sg13g2_decap_8
XFILLER_14_942 VPWR VGND sg13g2_decap_4
X_603_ _603_/Q _607_/CLK _603_/D fanout92/X VPWR VGND sg13g2_dfrbpq_1
X_534_ _534_/Q _542_/CLK _534_/D fanout83/X VPWR VGND sg13g2_dfrbpq_1
X_465_ _630_/D _319_/B _323_/Y _630_/Q VPWR VGND sg13g2_a21o_1
X_396_ _561_/D _560_/Q _561_/Q _397_/S VPWR VGND sg13g2_mux2_1
XFILLER_4_194 VPWR VGND sg13g2_fill_1
XFILLER_1_890 VPWR VGND sg13g2_decap_8
XFILLER_32_783 VPWR VGND sg13g2_decap_8
XFILLER_32_772 VPWR VGND sg13g2_fill_1
XFILLER_48_38 VPWR VGND sg13g2_fill_2
XFILLER_11_912 VPWR VGND sg13g2_decap_8
XFILLER_11_989 VPWR VGND sg13g2_decap_8
Xfanout42 _459_/S _457_/S VPWR VGND sg13g2_buf_1
Xfanout53 _439_/S _441_/S VPWR VGND sg13g2_buf_1
Xfanout64 _282_/B _283_/B VPWR VGND sg13g2_buf_1
Xfanout75 fanout75/X fanout76/X VPWR VGND sg13g2_buf_1
Xfanout86 fanout86/X fanout89/X VPWR VGND sg13g2_buf_1
Xfanout97 fanout97/X fanout98/X VPWR VGND sg13g2_buf_1
X_250_ _250_/Y _632_/Q VPWR VGND sg13g2_inv_1
XFILLER_7_949 VPWR VGND sg13g2_decap_8
XFILLER_23_772 VPWR VGND sg13g2_decap_8
XFILLER_2_654 VPWR VGND sg13g2_decap_8
XFILLER_38_809 VPWR VGND sg13g2_decap_8
XFILLER_14_772 VPWR VGND sg13g2_decap_8
X_517_ _517_/Q _539_/CLK _517_/D fanout90/X VPWR VGND sg13g2_dfrbpq_1
X_448_ _613_/D _612_/Q _640_/D _460_/S VPWR VGND sg13g2_mux2_1
Xclkload12 clkload12/Y _539_/CLK VPWR VGND sg13g2_inv_1
X_379_ _544_/D _543_/Q _544_/Q _460_/S VPWR VGND sg13g2_mux2_1
XFILLER_6_993 VPWR VGND sg13g2_decap_8
XFILLER_5_481 VPWR VGND sg13g2_fill_2
XFILLER_20_786 VPWR VGND sg13g2_decap_8
Xclkload6 clkload6/Y _656_/CLK VPWR VGND sg13g2_inv_1
X_302_ _666_/D _644_/Q _658_/Q _303_/S VPWR VGND sg13g2_mux2_1
XFILLER_43_801 VPWR VGND sg13g2_decap_8
XFILLER_11_786 VPWR VGND sg13g2_decap_8
XFILLER_3_941 VPWR VGND sg13g2_decap_8
XFILLER_45_171 VPWR VGND sg13g2_fill_1
XFILLER_40_804 VPWR VGND sg13g2_decap_8
Xu_delay_line_125 u_delay_line_125/L_HI VPWR VGND sg13g2_tiehi
Xu_delay_line_114 u_delay_line/trim[9] VPWR VGND sg13g2_tiehi
Xu_delay_line_103 u_delay_line/sel[3] VPWR VGND sg13g2_tielo
XFILLER_0_944 VPWR VGND sg13g2_decap_8
XFILLER_1_708 VPWR VGND sg13g2_decap_8
Xoutput19 uio_oe[5] _282_/X VPWR VGND sg13g2_buf_1
Xclkbuf_5_20__f_clk_regs _607_/CLK clkbuf_4_10_0_clk_regs/X VPWR VGND sg13g2_buf_16
XFILLER_0_741 VPWR VGND sg13g2_decap_8
XFILLER_48_745 VPWR VGND sg13g2_decap_8
XFILLER_12_870 VPWR VGND sg13g2_decap_8
XFILLER_8_863 VPWR VGND sg13g2_decap_8
XFILLER_7_54 VPWR VGND sg13g2_fill_2
XFILLER_10_807 VPWR VGND sg13g2_decap_8
Xclkbuf_5_4__f_clk_regs _655_/CLK clkbuf_4_2_0_clk_regs/X VPWR VGND sg13g2_buf_16
X_550_ _550_/Q _560_/CLK _550_/D fanout79/X VPWR VGND sg13g2_dfrbpq_1
X_481_ _481_/Y _488_/A _483_/B VPWR VGND sg13g2_xnor2_1
XFILLER_45_726 VPWR VGND sg13g2_fill_2
XFILLER_5_855 VPWR VGND sg13g2_decap_8
X_679_ _679_/Q _686_/CLK _679_/D fanout78/X VPWR VGND sg13g2_dfrbpq_1
XFILLER_44_770 VPWR VGND sg13g2_decap_8
Xhold137 _679_/D _687_/Q VPWR VGND sg13g2_dlygate4sd3_1
XFILLER_2_1018 VPWR VGND sg13g2_decap_8
XFILLER_35_792 VPWR VGND sg13g2_decap_8
XFILLER_2_836 VPWR VGND sg13g2_decap_8
X_602_ _602_/Q _607_/CLK _602_/D fanout99/X VPWR VGND sg13g2_dfrbpq_1
X_533_ _533_/Q _647_/CLK _533_/D fanout83/X VPWR VGND sg13g2_dfrbpq_1
X_464_ _629_/D _628_/Q _629_/Q _464_/S VPWR VGND sg13g2_mux2_1
X_395_ _560_/D _559_/Q _560_/Q _398_/S VPWR VGND sg13g2_mux2_1
XFILLER_4_88 VPWR VGND sg13g2_fill_1
XFILLER_11_968 VPWR VGND sg13g2_decap_8
Xfanout43 _457_/S fanout50/X VPWR VGND sg13g2_buf_1
Xfanout54 _407_/S _411_/S VPWR VGND sg13g2_buf_1
Xfanout65 fanout65/X fanout66/X VPWR VGND sg13g2_buf_1
Xfanout76 fanout76/X fanout77/X VPWR VGND sg13g2_buf_1
Xfanout87 fanout87/X fanout88/X VPWR VGND sg13g2_buf_1
Xfanout98 fanout98/X fanout99/X VPWR VGND sg13g2_buf_1
XFILLER_7_928 VPWR VGND sg13g2_decap_8
XFILLER_8_2 VPWR VGND sg13g2_fill_1
X_516_ _516_/Q _516_/CLK _516_/D fanout87/X VPWR VGND sg13g2_dfrbpq_1
X_447_ _612_/D _638_/D _612_/Q _460_/S VPWR VGND sg13g2_mux2_1
X_378_ _543_/D _542_/Q _543_/Q _407_/S VPWR VGND sg13g2_mux2_1
Xclkload13 clkload13/Y _601_/CLK VPWR VGND sg13g2_inv_1
XFILLER_6_972 VPWR VGND sg13g2_decap_8
XFILLER_37_821 VPWR VGND sg13g2_decap_8
XFILLER_20_765 VPWR VGND sg13g2_decap_8
Xclkload7 clkload7/Y _649_/CLK VPWR VGND sg13g2_inv_1
XFILLER_8_1024 VPWR VGND sg13g2_decap_4
XFILLER_46_117 VPWR VGND sg13g2_fill_2
XFILLER_28_821 VPWR VGND sg13g2_decap_8
X_301_ _665_/D _643_/Q _657_/Q _303_/S VPWR VGND sg13g2_mux2_1
XFILLER_11_765 VPWR VGND sg13g2_decap_8
XFILLER_7_769 VPWR VGND sg13g2_fill_2
XFILLER_3_920 VPWR VGND sg13g2_decap_8
XFILLER_3_997 VPWR VGND sg13g2_decap_8
XFILLER_2_430 VPWR VGND sg13g2_decap_8
XFILLER_19_821 VPWR VGND sg13g2_decap_8
XFILLER_34_824 VPWR VGND sg13g2_decap_8
Xu_delay_line_104 u_delay_line/sel[2] VPWR VGND sg13g2_tiehi
Xu_delay_line_126 u_delay_line_126/L_HI VPWR VGND sg13g2_tiehi
Xu_delay_line_115 u_delay_line_115/L_HI VPWR VGND sg13g2_tiehi
XFILLER_3_216 VPWR VGND sg13g2_fill_2
XFILLER_0_923 VPWR VGND sg13g2_decap_8
XFILLER_31_816 VPWR VGND sg13g2_decap_8
XFILLER_3_794 VPWR VGND sg13g2_decap_8
XFILLER_2_282 VPWR VGND sg13g2_fill_1
Xclkbuf_5_3__f_clk_regs _652_/CLK clkbuf_4_1_0_clk_regs/X VPWR VGND sg13g2_buf_16
XFILLER_5_1027 VPWR VGND sg13g2_fill_2
XFILLER_5_1016 VPWR VGND sg13g2_decap_8
XFILLER_13_849 VPWR VGND sg13g2_decap_8
XFILLER_0_720 VPWR VGND sg13g2_decap_8
XFILLER_0_797 VPWR VGND sg13g2_decap_8
XFILLER_8_842 VPWR VGND sg13g2_decap_8
X_480_ _480_/Y _488_/A _484_/B VPWR VGND sg13g2_xnor2_1
XFILLER_5_834 VPWR VGND sg13g2_decap_8
XFILLER_4_322 VPWR VGND sg13g2_fill_1
XFILLER_0_572 VPWR VGND sg13g2_fill_2
X_678_ _678_/Q _686_/CLK _678_/D fanout78/X VPWR VGND sg13g2_dfrbpq_1
Xhold138 _655_/D _626_/Q VPWR VGND sg13g2_dlygate4sd3_1
XFILLER_2_815 VPWR VGND sg13g2_decap_8
X_601_ _601_/Q _601_/CLK _601_/D fanout92/X VPWR VGND sg13g2_dfrbpq_1
XFILLER_45_502 VPWR VGND sg13g2_fill_2
XFILLER_14_966 VPWR VGND sg13g2_decap_4
XFILLER_14_988 VPWR VGND sg13g2_decap_8
X_532_ _532_/Q _647_/CLK _532_/D fanout83/X VPWR VGND sg13g2_dfrbpq_1
X_463_ _628_/D _627_/Q _628_/Q _463_/S VPWR VGND sg13g2_mux2_1
X_394_ _559_/D _558_/Q _559_/Q _398_/S VPWR VGND sg13g2_mux2_1
XFILLER_26_793 VPWR VGND sg13g2_decap_8
Xclkbuf_4_6_0_clk_regs clkbuf_4_6_0_clk_regs/X clkbuf_0_clk_regs/X VPWR VGND sg13g2_buf_8
XFILLER_5_664 VPWR VGND sg13g2_decap_4
XFILLER_17_793 VPWR VGND sg13g2_decap_8
Xfanout44 _460_/S fanout50/X VPWR VGND sg13g2_buf_1
Xfanout55 _411_/S _441_/S VPWR VGND sg13g2_buf_1
XFILLER_11_947 VPWR VGND sg13g2_decap_8
Xfanout66 fanout66/X fanout67/X VPWR VGND sg13g2_buf_1
Xfanout77 fanout77/X fanout80/X VPWR VGND sg13g2_buf_1
Xfanout88 fanout88/X fanout89/X VPWR VGND sg13g2_buf_1
Xfanout99 fanout99/X fanout99/A VPWR VGND sg13g2_buf_1
XFILLER_7_907 VPWR VGND sg13g2_decap_8
XFILLER_1_199 VPWR VGND sg13g2_fill_2
XFILLER_2_689 VPWR VGND sg13g2_decap_8
XFILLER_2_612 VPWR VGND sg13g2_decap_8
X_515_ _515_/Q _570_/CLK _515_/D fanout87/X VPWR VGND sg13g2_dfrbpq_1
X_446_ _611_/D _637_/D _638_/D _463_/S VPWR VGND sg13g2_mux2_1
X_377_ _542_/D _541_/Q _542_/Q _443_/S VPWR VGND sg13g2_mux2_1
Xclkload14 clkload14/Y _633_/CLK VPWR VGND sg13g2_inv_1
XFILLER_6_951 VPWR VGND sg13g2_decap_8
XFILLER_37_800 VPWR VGND sg13g2_decap_8
Xclkload8 clkload8/Y _653_/CLK VPWR VGND sg13g2_inv_1
XFILLER_8_1003 VPWR VGND sg13g2_decap_8
XFILLER_28_800 VPWR VGND sg13g2_decap_8
X_300_ _664_/D _642_/Q _656_/Q _303_/S VPWR VGND sg13g2_mux2_1
XFILLER_19_800 VPWR VGND sg13g2_decap_8
XFILLER_3_976 VPWR VGND sg13g2_decap_8
XFILLER_34_803 VPWR VGND sg13g2_decap_8
X_429_ _594_/D _593_/Q _594_/Q _431_/S VPWR VGND sg13g2_mux2_1
Xclkbuf_5_2__f_clk_regs _629_/CLK clkbuf_4_1_0_clk_regs/X VPWR VGND sg13g2_buf_16
Xinput1 input1/X rst_n VPWR VGND sg13g2_buf_1
XFILLER_25_814 VPWR VGND sg13g2_decap_8
Xu_delay_line_127 u_delay_line_127/L_HI VPWR VGND sg13g2_tiehi
Xu_delay_line_116 u_delay_line_116/L_HI VPWR VGND sg13g2_tiehi
Xu_delay_line_105 u_delay_line/trim[0] VPWR VGND sg13g2_tiehi
XFILLER_4_729 VPWR VGND sg13g2_decap_8
XFILLER_0_902 VPWR VGND sg13g2_decap_8
XFILLER_0_979 VPWR VGND sg13g2_decap_8
XFILLER_16_814 VPWR VGND sg13g2_decap_8
XFILLER_3_773 VPWR VGND sg13g2_decap_8
XFILLER_22_828 VPWR VGND sg13g2_decap_8
XFILLER_13_828 VPWR VGND sg13g2_decap_8
Xdelaybuf_2_clk delaybuf_3_clk/A delaybuf_2_clk/A VPWR VGND sg13g2_buf_16
XFILLER_0_776 VPWR VGND sg13g2_decap_8
XFILLER_48_703 VPWR VGND sg13g2_fill_2
XFILLER_8_898 VPWR VGND sg13g2_decap_8
XFILLER_8_821 VPWR VGND sg13g2_decap_8
XFILLER_3_570 VPWR VGND sg13g2_decap_8
XFILLER_47_791 VPWR VGND sg13g2_decap_8
XFILLER_45_728 VPWR VGND sg13g2_fill_1
XFILLER_5_813 VPWR VGND sg13g2_decap_8
X_677_ _677_/Q _677_/CLK _677_/D fanout86/X VPWR VGND sg13g2_dfrbpq_1
Xhold139 _642_/D _615_/Q VPWR VGND sg13g2_dlygate4sd3_1
XFILLER_4_890 VPWR VGND sg13g2_decap_8
X_600_ _600_/Q _601_/CLK _600_/D fanout99/X VPWR VGND sg13g2_dfrbpq_1
X_531_ _531_/Q _648_/CLK _531_/D fanout83/X VPWR VGND sg13g2_dfrbpq_1
XFILLER_14_934 VPWR VGND sg13g2_decap_4
X_462_ _627_/D _626_/Q _627_/Q _463_/S VPWR VGND sg13g2_mux2_1
X_393_ _558_/D _557_/Q _558_/Q _460_/S VPWR VGND sg13g2_mux2_1
XFILLER_26_772 VPWR VGND sg13g2_decap_8
XFILLER_5_632 VPWR VGND sg13g2_decap_8
XFILLER_17_772 VPWR VGND sg13g2_decap_8
XFILLER_9_982 VPWR VGND sg13g2_decap_8
XFILLER_32_797 VPWR VGND sg13g2_decap_8
XFILLER_11_926 VPWR VGND sg13g2_decap_8
Xfanout45 _398_/S fanout50/X VPWR VGND sg13g2_buf_1
Xfanout56 _441_/S _433_/S VPWR VGND sg13g2_buf_1
Xfanout67 fanout67/X fanout72/X VPWR VGND sg13g2_buf_1
Xfanout78 fanout78/X fanout80/X VPWR VGND sg13g2_buf_1
Xfanout89 fanout89/X fanout99/A VPWR VGND sg13g2_buf_1
XFILLER_23_786 VPWR VGND sg13g2_decap_8
XFILLER_13_55 VPWR VGND sg13g2_fill_1
X_514_ _514_/Q _576_/CLK _514_/D fanout94/X VPWR VGND sg13g2_dfrbpq_1
XFILLER_46_823 VPWR VGND sg13g2_decap_8
XFILLER_14_786 VPWR VGND sg13g2_decap_8
Xclkload15 clkload15/Y _576_/CLK VPWR VGND sg13g2_inv_1
X_445_ _610_/D _636_/D _637_/D _457_/S VPWR VGND sg13g2_mux2_1
X_376_ _541_/D _540_/Q _541_/Q _376_/S VPWR VGND sg13g2_mux2_1
XFILLER_6_930 VPWR VGND sg13g2_decap_8
Xclkbuf_5_1__f_clk_regs _658_/CLK clkbuf_4_0_0_clk_regs/X VPWR VGND sg13g2_buf_16
Xclkload9 clkload9/Y _688_/CLK VPWR VGND sg13g2_inv_1
Xclkbuf_1_1__f__017__regs _489_/CLK clkbuf_0__017__regs/X VPWR VGND sg13g2_buf_16
XFILLER_3_955 VPWR VGND sg13g2_decap_8
XFILLER_2_498 VPWR VGND sg13g2_fill_2
X_428_ _593_/D _592_/Q _593_/Q _431_/S VPWR VGND sg13g2_mux2_1
XFILLER_14_1009 VPWR VGND sg13g2_fill_2
X_359_ _524_/D _523_/Q _524_/Q _439_/S VPWR VGND sg13g2_mux2_1
Xinput2 _319_/B ui_in[0] VPWR VGND sg13g2_buf_1
Xu_delay_line_128 u_delay_line_128/L_HI VPWR VGND sg13g2_tiehi
Xu_delay_line_117 u_delay_line_117/L_HI VPWR VGND sg13g2_tiehi
Xu_delay_line_106 u_delay_line/trim[1] VPWR VGND sg13g2_tiehi
XFILLER_40_818 VPWR VGND sg13g2_decap_8
XFILLER_4_708 VPWR VGND sg13g2_decap_8
XFILLER_0_958 VPWR VGND sg13g2_decap_8
XFILLER_3_752 VPWR VGND sg13g2_decap_8
XFILLER_22_807 VPWR VGND sg13g2_decap_8
XFILLER_13_807 VPWR VGND sg13g2_decap_8
XFILLER_0_755 VPWR VGND sg13g2_decap_8
XFILLER_48_759 VPWR VGND sg13g2_decap_8
XFILLER_8_800 VPWR VGND sg13g2_decap_8
XFILLER_12_884 VPWR VGND sg13g2_decap_8
XFILLER_8_877 VPWR VGND sg13g2_decap_8
XFILLER_47_770 VPWR VGND sg13g2_decap_8
XFILLER_5_869 VPWR VGND sg13g2_decap_8
X_676_ _676_/Q _676_/CLK _676_/D fanout76/X VPWR VGND sg13g2_dfrbpq_1
XFILLER_44_784 VPWR VGND sg13g2_decap_8
XFILLER_1_349 VPWR VGND sg13g2_fill_2
X_530_ _530_/Q _542_/CLK _530_/D fanout83/X VPWR VGND sg13g2_dfrbpq_1
X_461_ _626_/D _654_/D _626_/Q _463_/S VPWR VGND sg13g2_mux2_1
XFILLER_14_957 VPWR VGND sg13g2_decap_4
X_392_ _557_/D _556_/Q _557_/Q _460_/S VPWR VGND sg13g2_mux2_1
XFILLER_41_798 VPWR VGND sg13g2_decap_8
Xclkbuf_5_0__f_clk_regs _651_/CLK clkbuf_4_0_0_clk_regs/X VPWR VGND sg13g2_buf_16
XFILLER_0_371 VPWR VGND sg13g2_decap_4
XFILLER_1_883 VPWR VGND sg13g2_decap_8
XFILLER_49_821 VPWR VGND sg13g2_decap_8
X_659_ _659_/Q _473_/Y _659_/D fanout67/X VPWR VGND sg13g2_dfrbpq_1
XFILLER_9_961 VPWR VGND sg13g2_decap_8
XFILLER_11_905 VPWR VGND sg13g2_decap_8
Xfanout46 _456_/S _455_/S VPWR VGND sg13g2_buf_1
Xfanout57 _442_/S _433_/S VPWR VGND sg13g2_buf_1
Xfanout68 fanout68/X fanout69/X VPWR VGND sg13g2_buf_1
Xfanout79 fanout79/X fanout80/X VPWR VGND sg13g2_buf_1
XFILLER_23_765 VPWR VGND sg13g2_decap_8
XFILLER_2_647 VPWR VGND sg13g2_decap_8
XFILLER_46_802 VPWR VGND sg13g2_decap_8
XFILLER_14_765 VPWR VGND sg13g2_decap_8
X_513_ _513_/Q _576_/CLK _513_/D fanout94/X VPWR VGND sg13g2_dfrbpq_1
X_444_ _609_/D _635_/D _636_/D _456_/S VPWR VGND sg13g2_mux2_1
XFILLER_10_982 VPWR VGND sg13g2_decap_8
Xclkload16 clkload16/Y _573_/CLK VPWR VGND sg13g2_inv_1
X_375_ _540_/D _539_/Q _540_/Q _443_/S VPWR VGND sg13g2_mux2_1
XFILLER_1_680 VPWR VGND sg13g2_decap_8
XFILLER_6_986 VPWR VGND sg13g2_decap_8
XFILLER_20_779 VPWR VGND sg13g2_decap_8
XFILLER_11_779 VPWR VGND sg13g2_decap_8
XFILLER_3_934 VPWR VGND sg13g2_decap_8
XFILLER_2_444 VPWR VGND sg13g2_fill_1
X_427_ _592_/D _591_/Q _592_/Q _427_/S VPWR VGND sg13g2_mux2_1
X_358_ _523_/D _522_/Q _523_/Q _439_/S VPWR VGND sg13g2_mux2_1
X_289_ _294_/B _303_/S _645_/Q VPWR VGND sg13g2_nand2_1
Xdelaybuf_21_clk delaybuf_22_clk/A delaybuf_21_clk/A VPWR VGND sg13g2_buf_16
Xinput3 input3/X ui_in[1] VPWR VGND sg13g2_buf_1
Xu_delay_line_118 u_delay_line_118/L_HI VPWR VGND sg13g2_tiehi
Xu_delay_line_107 u_delay_line/trim[2] VPWR VGND sg13g2_tiehi
XFILLER_0_937 VPWR VGND sg13g2_decap_8
Xdelaybuf_12_clk delaybuf_13_clk/A delaybuf_12_clk/A VPWR VGND sg13g2_buf_16
XFILLER_13_1010 VPWR VGND sg13g2_decap_4
XFILLER_3_731 VPWR VGND sg13g2_decap_8
XFILLER_46_440 VPWR VGND sg13g2_fill_1
Xclkbuf_1_0__f__017_ _286_/B clkbuf_0__017_/X VPWR VGND sg13g2_buf_16
XFILLER_0_734 VPWR VGND sg13g2_decap_8
XFILLER_12_863 VPWR VGND sg13g2_decap_8
XFILLER_8_856 VPWR VGND sg13g2_decap_8
XFILLER_5_848 VPWR VGND sg13g2_decap_8
X_675_ _675_/Q _675_/CLK _675_/D fanout75/X VPWR VGND sg13g2_dfrbpq_1
XFILLER_44_763 VPWR VGND sg13g2_decap_8
XFILLER_29_793 VPWR VGND sg13g2_decap_8
XFILLER_35_785 VPWR VGND sg13g2_decap_8
XFILLER_2_829 VPWR VGND sg13g2_decap_8
XFILLER_14_914 VPWR VGND sg13g2_fill_2
X_460_ _625_/D _653_/D _654_/D _460_/S VPWR VGND sg13g2_mux2_1
X_391_ _556_/D _555_/Q _556_/Q _459_/S VPWR VGND sg13g2_mux2_1
XFILLER_1_862 VPWR VGND sg13g2_decap_8
XFILLER_49_800 VPWR VGND sg13g2_decap_8
X_589_ _589_/Q _591_/CLK _589_/D fanout97/X VPWR VGND sg13g2_dfrbpq_1
X_658_ _658_/Q _658_/CLK _658_/D fanout67/X VPWR VGND sg13g2_dfrbpq_1
XFILLER_9_940 VPWR VGND sg13g2_decap_8
Xfanout47 _455_/S _350_/S VPWR VGND sg13g2_buf_1
Xfanout58 _431_/S _419_/S VPWR VGND sg13g2_buf_1
Xfanout69 fanout69/X fanout72/X VPWR VGND sg13g2_buf_1
XFILLER_2_626 VPWR VGND sg13g2_decap_4
X_512_ _512_/Q _580_/CLK _512_/D fanout94/X VPWR VGND sg13g2_dfrbpq_1
X_443_ _608_/D _634_/D _635_/D _443_/S VPWR VGND sg13g2_mux2_1
X_374_ _539_/D _538_/Q _539_/Q _443_/S VPWR VGND sg13g2_mux2_1
XFILLER_10_961 VPWR VGND sg13g2_decap_8
Xclkload17 clkload17/Y _596_/CLK VPWR VGND sg13g2_inv_1
XFILLER_6_965 VPWR VGND sg13g2_decap_8
Xclkbuf_leaf_0_clk _487_/B clkbuf_leaf_6_clk/A VPWR VGND sg13g2_buf_8
XFILLER_37_814 VPWR VGND sg13g2_decap_8
XFILLER_5_91 VPWR VGND sg13g2_fill_1
Xclkbuf_4_5_0_clk_regs clkbuf_4_5_0_clk_regs/X clkbuf_0_clk_regs/X VPWR VGND sg13g2_buf_8
XFILLER_8_1028 VPWR VGND sg13g2_fill_1
XFILLER_8_1017 VPWR VGND sg13g2_decap_8
XFILLER_28_814 VPWR VGND sg13g2_decap_8
XFILLER_3_913 VPWR VGND sg13g2_decap_8
XFILLER_2_412 VPWR VGND sg13g2_decap_8
XFILLER_19_814 VPWR VGND sg13g2_decap_8
XFILLER_34_817 VPWR VGND sg13g2_decap_8
X_426_ _591_/D _590_/Q _591_/Q _427_/S VPWR VGND sg13g2_mux2_1
X_357_ _522_/D _521_/Q _522_/Q _443_/S VPWR VGND sg13g2_mux2_1
X_288_ _294_/A _675_/D _631_/Q VPWR VGND sg13g2_nand2_1
Xinput4 _309_/A ui_in[2] VPWR VGND sg13g2_buf_1
XFILLER_2_990 VPWR VGND sg13g2_decap_8
XFILLER_25_828 VPWR VGND sg13g2_decap_8
Xu_delay_line_119 u_delay_line_119/L_HI VPWR VGND sg13g2_tiehi
Xu_delay_line_108 u_delay_line/trim[3] VPWR VGND sg13g2_tiehi
XFILLER_0_916 VPWR VGND sg13g2_decap_8
XFILLER_16_828 VPWR VGND sg13g2_decap_8
XFILLER_31_809 VPWR VGND sg13g2_decap_8
Xdelaybuf_5_clk delaybuf_6_clk/A delaybuf_5_clk/A VPWR VGND sg13g2_buf_16
XFILLER_4_0 VPWR VGND sg13g2_fill_2
XFILLER_3_710 VPWR VGND sg13g2_decap_8
XFILLER_3_787 VPWR VGND sg13g2_decap_8
X_409_ _574_/D _573_/Q _574_/Q _411_/S VPWR VGND sg13g2_mux2_1
XFILLER_5_1009 VPWR VGND sg13g2_decap_8
XFILLER_0_713 VPWR VGND sg13g2_decap_8
XFILLER_46_76 VPWR VGND sg13g2_fill_1
XFILLER_12_842 VPWR VGND sg13g2_decap_8
XFILLER_8_835 VPWR VGND sg13g2_decap_8
XFILLER_0_521 VPWR VGND sg13g2_fill_1
XFILLER_10_1003 VPWR VGND sg13g2_fill_1
XFILLER_5_827 VPWR VGND sg13g2_decap_8
XFILLER_4_337 VPWR VGND sg13g2_decap_4
XFILLER_0_532 VPWR VGND sg13g2_decap_8
XFILLER_0_543 VPWR VGND sg13g2_fill_2
X_674_ _674_/Q _488_/Y _675_/D fanout76/X VPWR VGND sg13g2_dfrbpq_1
XFILLER_29_772 VPWR VGND sg13g2_decap_8
XFILLER_2_808 VPWR VGND sg13g2_decap_8
X_390_ _555_/D _554_/Q _555_/Q _459_/S VPWR VGND sg13g2_mux2_1
XFILLER_26_786 VPWR VGND sg13g2_decap_8
XFILLER_5_657 VPWR VGND sg13g2_decap_8
XFILLER_5_613 VPWR VGND sg13g2_fill_2
XFILLER_1_841 VPWR VGND sg13g2_decap_8
XFILLER_5_668 VPWR VGND sg13g2_fill_2
XFILLER_4_134 VPWR VGND sg13g2_fill_2
XFILLER_1_1023 VPWR VGND sg13g2_decap_4
X_657_ _657_/Q _658_/CLK _657_/D fanout67/X VPWR VGND sg13g2_dfrbpq_1
XFILLER_17_786 VPWR VGND sg13g2_decap_8
X_588_ _588_/Q _591_/CLK _588_/D fanout97/X VPWR VGND sg13g2_dfrbpq_1
XFILLER_9_996 VPWR VGND sg13g2_decap_8
Xfanout48 _397_/S _350_/S VPWR VGND sg13g2_buf_1
Xfanout59 _427_/S _419_/S VPWR VGND sg13g2_buf_1
XFILLER_2_605 VPWR VGND sg13g2_decap_8
X_511_ _511_/Q _633_/CLK _511_/D fanout96/X VPWR VGND sg13g2_dfrbpq_1
X_442_ _607_/D _606_/Q _634_/D _442_/S VPWR VGND sg13g2_mux2_1
X_373_ _538_/D _537_/Q _538_/Q _456_/S VPWR VGND sg13g2_mux2_1
XFILLER_10_940 VPWR VGND sg13g2_decap_8
Xclkload18 clkload18/Y _489_/CLK VPWR VGND sg13g2_inv_1
XFILLER_6_944 VPWR VGND sg13g2_decap_8
XFILLER_5_432 VPWR VGND sg13g2_decap_4
XFILLER_9_793 VPWR VGND sg13g2_decap_8
XFILLER_3_969 VPWR VGND sg13g2_decap_8
XFILLER_2_479 VPWR VGND sg13g2_decap_4
XFILLER_45_133 VPWR VGND sg13g2_fill_1
X_425_ _590_/D _589_/Q _590_/Q _427_/S VPWR VGND sg13g2_mux2_1
X_356_ _521_/D _520_/Q _521_/Q _439_/S VPWR VGND sg13g2_mux2_1
X_287_ _676_/D _671_/Q _672_/Q VPWR VGND sg13g2_and2_1
XFILLER_5_240 VPWR VGND sg13g2_decap_8
Xinput5 _307_/B ui_in[3] VPWR VGND sg13g2_buf_1
XFILLER_25_807 VPWR VGND sg13g2_decap_8
Xu_delay_line_109 u_delay_line/trim[4] VPWR VGND sg13g2_tiehi
XFILLER_47_409 VPWR VGND sg13g2_fill_1
XFILLER_16_807 VPWR VGND sg13g2_decap_8
XFILLER_3_766 VPWR VGND sg13g2_decap_8
XFILLER_2_210 VPWR VGND sg13g2_decap_8
X_408_ _573_/D _572_/Q _573_/Q _411_/S VPWR VGND sg13g2_mux2_1
XFILLER_30_832 VPWR VGND sg13g2_fill_2
X_339_ _504_/D _504_/Q input3/X _339_/S VPWR VGND sg13g2_mux2_1
XANTENNA_10 ui_in[7] VPWR VGND sg13g2_antennanp
XFILLER_21_821 VPWR VGND sg13g2_decap_8
XFILLER_0_769 VPWR VGND sg13g2_decap_8
XFILLER_12_821 VPWR VGND sg13g2_decap_8
XFILLER_12_898 VPWR VGND sg13g2_decap_8
XFILLER_8_814 VPWR VGND sg13g2_decap_8
XFILLER_47_784 VPWR VGND sg13g2_decap_8
XFILLER_38_795 VPWR VGND sg13g2_decap_8
XFILLER_5_806 VPWR VGND sg13g2_decap_8
X_673_ _673_/Q _487_/Y _673_/D fanout76/X VPWR VGND sg13g2_dfrbpq_1
XFILLER_44_798 VPWR VGND sg13g2_decap_8
XFILLER_4_883 VPWR VGND sg13g2_decap_8
XFILLER_14_905 VPWR VGND sg13g2_decap_4
XFILLER_14_927 VPWR VGND sg13g2_decap_8
XFILLER_26_765 VPWR VGND sg13g2_decap_8
XFILLER_5_625 VPWR VGND sg13g2_decap_8
XFILLER_1_820 VPWR VGND sg13g2_decap_8
XFILLER_1_897 VPWR VGND sg13g2_decap_8
XFILLER_17_765 VPWR VGND sg13g2_decap_8
XFILLER_1_1002 VPWR VGND sg13g2_decap_8
X_587_ _587_/Q _591_/CLK _587_/D fanout98/X VPWR VGND sg13g2_dfrbpq_1
X_656_ _656_/Q _656_/CLK _656_/D fanout66/X VPWR VGND sg13g2_dfrbpq_1
XFILLER_13_982 VPWR VGND sg13g2_decap_8
XFILLER_9_975 VPWR VGND sg13g2_decap_8
XFILLER_12_0 VPWR VGND sg13g2_fill_2
XFILLER_11_919 VPWR VGND sg13g2_decap_8
Xfanout38 _303_/S _306_/S VPWR VGND sg13g2_buf_1
Xfanout49 _350_/S fanout50/X VPWR VGND sg13g2_buf_1
XFILLER_23_779 VPWR VGND sg13g2_decap_8
Xclkbuf_5_31__f_clk_regs _586_/CLK clkbuf_4_15_0_clk_regs/X VPWR VGND sg13g2_buf_16
X_510_ _510_/Q _539_/CLK _510_/D fanout94/X VPWR VGND sg13g2_dfrbpq_1
X_441_ _606_/D _605_/Q _606_/Q _441_/S VPWR VGND sg13g2_mux2_1
XFILLER_46_816 VPWR VGND sg13g2_decap_8
XFILLER_14_779 VPWR VGND sg13g2_decap_8
X_372_ _537_/D _536_/Q _537_/Q _456_/S VPWR VGND sg13g2_mux2_1
XFILLER_10_996 VPWR VGND sg13g2_decap_8
XFILLER_6_923 VPWR VGND sg13g2_decap_8
XFILLER_5_477 VPWR VGND sg13g2_decap_4
XFILLER_1_694 VPWR VGND sg13g2_decap_8
X_639_ _639_/Q _653_/CLK _639_/D fanout74/X VPWR VGND sg13g2_dfrbpq_1
XFILLER_9_772 VPWR VGND sg13g2_decap_8
Xdelaybuf_24_clk delaybuf_25_clk/A delaybuf_24_clk/A VPWR VGND sg13g2_buf_16
XFILLER_43_808 VPWR VGND sg13g2_fill_2
Xdelaybuf_15_clk delaybuf_15_clk/X _483_/B VPWR VGND sg13g2_buf_16
XFILLER_3_948 VPWR VGND sg13g2_decap_8
X_424_ _589_/D _588_/Q _589_/Q _427_/S VPWR VGND sg13g2_mux2_1
XFILLER_10_793 VPWR VGND sg13g2_decap_8
X_355_ _520_/D _519_/Q _520_/Q _439_/S VPWR VGND sg13g2_mux2_1
X_286_ _286_/Y _286_/A _286_/B VPWR VGND sg13g2_nor2_1
XFILLER_6_797 VPWR VGND sg13g2_decap_8
Xinput6 _631_/D ui_in[4] VPWR VGND sg13g2_buf_1
XFILLER_4_2 VPWR VGND sg13g2_fill_1
XFILLER_3_745 VPWR VGND sg13g2_decap_8
XFILLER_2_244 VPWR VGND sg13g2_decap_8
X_407_ _572_/D _571_/Q _572_/Q _407_/S VPWR VGND sg13g2_mux2_1
X_338_ _503_/D _503_/Q _338_/B VPWR VGND sg13g2_xnor2_1
XFILLER_30_811 VPWR VGND sg13g2_decap_8
X_269_ _269_/X _684_/Q _282_/B VPWR VGND sg13g2_and2_1
XANTENNA_11 uio_in[0] VPWR VGND sg13g2_antennanp
XFILLER_21_800 VPWR VGND sg13g2_decap_8
XFILLER_0_748 VPWR VGND sg13g2_decap_8
XFILLER_48_719 VPWR VGND sg13g2_fill_1
XFILLER_12_800 VPWR VGND sg13g2_decap_8
XFILLER_12_877 VPWR VGND sg13g2_decap_8
XFILLER_3_520 VPWR VGND sg13g2_fill_1
XFILLER_3_542 VPWR VGND sg13g2_fill_1
XFILLER_3_531 VPWR VGND sg13g2_decap_8
XFILLER_47_763 VPWR VGND sg13g2_decap_8
XFILLER_4_328 VPWR VGND sg13g2_fill_1
XFILLER_0_512 VPWR VGND sg13g2_decap_8
X_672_ _672_/Q _486_/Y _672_/D fanout76/X VPWR VGND sg13g2_dfrbpq_1
XFILLER_44_777 VPWR VGND sg13g2_decap_8
XFILLER_4_862 VPWR VGND sg13g2_decap_8
XFILLER_35_799 VPWR VGND sg13g2_decap_8
Xclkbuf_5_30__f_clk_regs _580_/CLK clkbuf_4_15_0_clk_regs/X VPWR VGND sg13g2_buf_16
XFILLER_41_769 VPWR VGND sg13g2_fill_2
XFILLER_4_158 VPWR VGND sg13g2_fill_2
XFILLER_0_331 VPWR VGND sg13g2_decap_4
XFILLER_0_364 VPWR VGND sg13g2_decap_8
XFILLER_1_876 VPWR VGND sg13g2_decap_8
XFILLER_49_814 VPWR VGND sg13g2_decap_8
X_586_ _586_/Q _586_/CLK _586_/D fanout98/X VPWR VGND sg13g2_dfrbpq_1
X_655_ _655_/Q _655_/CLK _655_/D fanout65/X VPWR VGND sg13g2_dfrbpq_1
XFILLER_13_961 VPWR VGND sg13g2_decap_8
XFILLER_9_954 VPWR VGND sg13g2_decap_8
Xclkbuf_leaf_3_clk _468_/B delaybuf_14_clk/X VPWR VGND sg13g2_buf_8
Xfanout39 _306_/S _674_/Q VPWR VGND sg13g2_buf_1
X_440_ _605_/D _604_/Q _605_/Q _442_/S VPWR VGND sg13g2_mux2_1
X_371_ _536_/D _535_/Q _536_/Q _456_/S VPWR VGND sg13g2_mux2_1
XFILLER_10_975 VPWR VGND sg13g2_decap_8
XFILLER_6_902 VPWR VGND sg13g2_decap_8
XFILLER_6_979 VPWR VGND sg13g2_decap_8
XFILLER_1_673 VPWR VGND sg13g2_decap_8
XFILLER_37_828 VPWR VGND sg13g2_decap_8
X_638_ _638_/Q _652_/CLK _638_/D fanout69/X VPWR VGND sg13g2_dfrbpq_1
X_569_ _569_/Q _652_/CLK _569_/D fanout69/X VPWR VGND sg13g2_dfrbpq_1
XFILLER_28_828 VPWR VGND sg13g2_decap_8
XFILLER_3_927 VPWR VGND sg13g2_decap_8
XFILLER_2_437 VPWR VGND sg13g2_decap_8
XFILLER_19_828 VPWR VGND sg13g2_decap_8
X_423_ _588_/D _587_/Q _588_/Q _431_/S VPWR VGND sg13g2_mux2_1
X_354_ _519_/D _518_/Q _519_/Q _439_/S VPWR VGND sg13g2_mux2_1
XFILLER_10_772 VPWR VGND sg13g2_decap_8
Xdelaybuf_8_clk delaybuf_9_clk/A clkload0/A VPWR VGND sg13g2_buf_16
XFILLER_6_765 VPWR VGND sg13g2_decap_4
Xinput7 _632_/D ui_in[5] VPWR VGND sg13g2_buf_1
XFILLER_19_37 VPWR VGND sg13g2_fill_1
XFILLER_13_1003 VPWR VGND sg13g2_decap_8
XFILLER_13_1014 VPWR VGND sg13g2_fill_1
XFILLER_3_724 VPWR VGND sg13g2_decap_8
XFILLER_2_278 VPWR VGND sg13g2_decap_4
Xclkbuf_4_4_0_clk_regs clkbuf_4_4_0_clk_regs/X clkbuf_0_clk_regs/X VPWR VGND sg13g2_buf_8
X_406_ _571_/D _570_/Q _571_/Q _407_/S VPWR VGND sg13g2_mux2_1
X_337_ _502_/D _335_/A _335_/B _336_/Y VPWR VGND sg13g2_a21oi_1
XFILLER_30_834 VPWR VGND sg13g2_fill_1
X_268_ _268_/X _683_/Q _282_/B VPWR VGND sg13g2_and2_1
XANTENNA_12 uio_in[1] VPWR VGND sg13g2_antennanp
XFILLER_0_727 VPWR VGND sg13g2_decap_8
XFILLER_12_856 VPWR VGND sg13g2_decap_8
XFILLER_8_849 VPWR VGND sg13g2_decap_8
XFILLER_4_1023 VPWR VGND sg13g2_decap_4
Xinput10 _264_/A0 uio_in[0] VPWR VGND sg13g2_buf_1
XFILLER_7_893 VPWR VGND sg13g2_decap_8
XFILLER_35_0 VPWR VGND sg13g2_fill_2
XFILLER_4_318 VPWR VGND sg13g2_decap_4
X_671_ _671_/Q _485_/Y _671_/D fanout76/X VPWR VGND sg13g2_dfrbpq_1
XFILLER_29_786 VPWR VGND sg13g2_decap_8
XFILLER_4_841 VPWR VGND sg13g2_decap_8
XFILLER_1_855 VPWR VGND sg13g2_decap_8
X_654_ _654_/Q _654_/CLK _654_/D fanout73/X VPWR VGND sg13g2_dfrbpq_1
XFILLER_13_940 VPWR VGND sg13g2_decap_8
X_585_ _585_/Q _591_/CLK _585_/D fanout98/X VPWR VGND sg13g2_dfrbpq_1
XFILLER_9_933 VPWR VGND sg13g2_decap_8
XFILLER_2_619 VPWR VGND sg13g2_decap_8
X_370_ _535_/D _534_/Q _535_/Q _456_/S VPWR VGND sg13g2_mux2_1
XFILLER_10_954 VPWR VGND sg13g2_decap_8
XFILLER_6_958 VPWR VGND sg13g2_decap_8
XFILLER_0_151 VPWR VGND sg13g2_fill_1
XFILLER_1_652 VPWR VGND sg13g2_decap_8
X_637_ _637_/Q _655_/CLK _637_/D fanout66/X VPWR VGND sg13g2_dfrbpq_1
XFILLER_37_807 VPWR VGND sg13g2_decap_8
X_568_ _568_/Q _629_/CLK _568_/D fanout68/X VPWR VGND sg13g2_dfrbpq_1
X_499_ _499_/Q _570_/CLK _499_/D fanout87/X VPWR VGND sg13g2_dfrbpq_1
XFILLER_28_807 VPWR VGND sg13g2_decap_8
XFILLER_3_906 VPWR VGND sg13g2_decap_8
XFILLER_2_405 VPWR VGND sg13g2_decap_8
XFILLER_19_807 VPWR VGND sg13g2_decap_8
X_422_ _587_/D _586_/Q _587_/Q _431_/S VPWR VGND sg13g2_mux2_1
X_353_ _518_/D _517_/Q _518_/Q _443_/S VPWR VGND sg13g2_mux2_1
X_284_ _284_/Y _488_/A _284_/B VPWR VGND sg13g2_xnor2_1
XFILLER_5_287 VPWR VGND sg13g2_fill_1
Xinput8 _645_/D ui_in[6] VPWR VGND sg13g2_buf_1
XFILLER_2_983 VPWR VGND sg13g2_decap_8
XFILLER_0_909 VPWR VGND sg13g2_decap_8
XFILLER_10_18 VPWR VGND sg13g2_fill_1
XFILLER_24_821 VPWR VGND sg13g2_decap_8
XFILLER_3_703 VPWR VGND sg13g2_decap_8
XFILLER_15_821 VPWR VGND sg13g2_decap_8
X_405_ _570_/D _569_/Q _570_/Q _407_/S VPWR VGND sg13g2_mux2_1
X_336_ _336_/Y _501_/Q _335_/B _502_/Q VPWR VGND sg13g2_a21oi_1
X_267_ _267_/X _682_/Q _282_/B VPWR VGND sg13g2_and2_1
XFILLER_2_780 VPWR VGND sg13g2_decap_8
XANTENNA_13 uio_in[2] VPWR VGND sg13g2_antennanp
XFILLER_0_706 VPWR VGND sg13g2_decap_8
XFILLER_12_835 VPWR VGND sg13g2_decap_8
XFILLER_8_828 VPWR VGND sg13g2_decap_8
XFILLER_3_577 VPWR VGND sg13g2_fill_2
XFILLER_4_1002 VPWR VGND sg13g2_decap_8
XFILLER_47_798 VPWR VGND sg13g2_decap_8
Xinput11 _263_/A0 uio_in[1] VPWR VGND sg13g2_buf_1
X_319_ _319_/Y _630_/Q _319_/B VPWR VGND sg13g2_nand2b_1
XFILLER_7_872 VPWR VGND sg13g2_decap_8
Xclkbuf_1_0__f_clk clkbuf_leaf_6_clk/A delaybuf_22_clk/X VPWR VGND sg13g2_buf_16
X_670_ _670_/Q _484_/Y _670_/D fanout71/X VPWR VGND sg13g2_dfrbpq_1
XFILLER_48_507 VPWR VGND sg13g2_fill_2
XFILLER_29_765 VPWR VGND sg13g2_decap_8
XFILLER_4_820 VPWR VGND sg13g2_decap_8
XFILLER_4_897 VPWR VGND sg13g2_decap_8
XFILLER_26_779 VPWR VGND sg13g2_decap_8
XFILLER_5_639 VPWR VGND sg13g2_fill_1
XFILLER_5_606 VPWR VGND sg13g2_decap_8
XFILLER_1_834 VPWR VGND sg13g2_decap_8
XFILLER_1_1016 VPWR VGND sg13g2_decap_8
XFILLER_1_1027 VPWR VGND sg13g2_fill_2
X_653_ _653_/Q _653_/CLK _653_/D fanout74/X VPWR VGND sg13g2_dfrbpq_1
XFILLER_13_996 VPWR VGND sg13g2_decap_8
XFILLER_17_779 VPWR VGND sg13g2_decap_8
X_584_ _584_/Q _586_/CLK _584_/D fanout98/X VPWR VGND sg13g2_dfrbpq_1
XFILLER_9_912 VPWR VGND sg13g2_decap_8
XFILLER_9_989 VPWR VGND sg13g2_decap_8
XFILLER_3_160 VPWR VGND sg13g2_fill_2
Xdelaybuf_27_clk delaybuf_28_clk/A delaybuf_27_clk/A VPWR VGND sg13g2_buf_16
XFILLER_10_933 VPWR VGND sg13g2_decap_8
Xdelaybuf_18_clk delaybuf_19_clk/A delaybuf_18_clk/A VPWR VGND sg13g2_buf_16
XFILLER_6_937 VPWR VGND sg13g2_decap_8
XFILLER_5_447 VPWR VGND sg13g2_fill_2
XFILLER_5_436 VPWR VGND sg13g2_fill_1
XFILLER_5_425 VPWR VGND sg13g2_decap_8
XFILLER_5_403 VPWR VGND sg13g2_decap_4
XFILLER_22_793 VPWR VGND sg13g2_decap_8
XFILLER_1_631 VPWR VGND sg13g2_decap_8
XFILLER_48_123 VPWR VGND sg13g2_fill_1
X_636_ _636_/Q _650_/CLK _636_/D fanout71/X VPWR VGND sg13g2_dfrbpq_1
X_567_ _567_/Q _629_/CLK _567_/D fanout68/X VPWR VGND sg13g2_dfrbpq_1
XFILLER_13_793 VPWR VGND sg13g2_decap_8
X_498_ _498_/Q _570_/CLK _498_/D fanout87/X VPWR VGND sg13g2_dfrbpq_1
XFILLER_9_786 VPWR VGND sg13g2_decap_8
XFILLER_5_981 VPWR VGND sg13g2_decap_8
XFILLER_4_491 VPWR VGND sg13g2_fill_1
X_421_ _586_/D _585_/Q _586_/Q _431_/S VPWR VGND sg13g2_mux2_1
XFILLER_42_822 VPWR VGND sg13g2_decap_8
X_352_ _517_/D _516_/Q _517_/Q _443_/S VPWR VGND sg13g2_mux2_1
X_283_ _283_/X _673_/Q _283_/B VPWR VGND sg13g2_and2_1
XFILLER_42_833 VPWR VGND sg13g2_fill_2
XFILLER_5_233 VPWR VGND sg13g2_decap_8
Xinput9 _646_/D ui_in[7] VPWR VGND sg13g2_buf_1
XFILLER_2_962 VPWR VGND sg13g2_decap_8
X_619_ _619_/Q _647_/CLK _619_/D fanout82/X VPWR VGND sg13g2_dfrbpq_1
XFILLER_33_833 VPWR VGND sg13g2_fill_2
XFILLER_33_822 VPWR VGND sg13g2_decap_8
XFILLER_24_800 VPWR VGND sg13g2_decap_8
XFILLER_13_1027 VPWR VGND sg13g2_fill_2
XFILLER_3_759 VPWR VGND sg13g2_decap_8
XFILLER_15_800 VPWR VGND sg13g2_decap_8
X_404_ _569_/D _568_/Q _569_/Q _457_/S VPWR VGND sg13g2_mux2_1
X_335_ _338_/B _335_/A _335_/B VPWR VGND sg13g2_nand2_1
X_266_ _286_/A _282_/B VPWR VGND sg13g2_inv_1
XFILLER_30_825 VPWR VGND sg13g2_decap_8
XANTENNA_14 uio_in[2] VPWR VGND sg13g2_antennanp
XFILLER_21_814 VPWR VGND sg13g2_decap_8
XFILLER_12_814 VPWR VGND sg13g2_decap_8
XFILLER_8_807 VPWR VGND sg13g2_decap_8
XFILLER_3_589 VPWR VGND sg13g2_decap_4
XFILLER_47_777 VPWR VGND sg13g2_decap_8
XFILLER_11_891 VPWR VGND sg13g2_decap_8
Xinput12 _262_/A0 uio_in[2] VPWR VGND sg13g2_buf_1
X_318_ _339_/S _630_/Q _319_/B VPWR VGND sg13g2_nor2b_1
X_249_ _675_/D _303_/S VPWR VGND sg13g2_inv_1
XFILLER_7_851 VPWR VGND sg13g2_decap_8
XFILLER_4_876 VPWR VGND sg13g2_decap_8
XFILLER_43_780 VPWR VGND sg13g2_decap_8
Xclkbuf_leaf_6_clk _478_/B clkbuf_leaf_6_clk/A VPWR VGND sg13g2_buf_8
XFILLER_14_909 VPWR VGND sg13g2_fill_1
XFILLER_0_345 VPWR VGND sg13g2_decap_4
XFILLER_1_813 VPWR VGND sg13g2_decap_8
XFILLER_49_828 VPWR VGND sg13g2_decap_8
X_583_ _583_/Q _586_/CLK _583_/D fanout98/X VPWR VGND sg13g2_dfrbpq_1
X_652_ _652_/Q _652_/CLK _652_/D fanout69/X VPWR VGND sg13g2_dfrbpq_1
XFILLER_13_975 VPWR VGND sg13g2_decap_8
XFILLER_9_968 VPWR VGND sg13g2_decap_8
XFILLER_46_809 VPWR VGND sg13g2_decap_8
XFILLER_10_912 VPWR VGND sg13g2_decap_8
Xclkbuf_0__017_ clkbuf_0__017_/X _284_/Y VPWR VGND sg13g2_buf_16
XFILLER_22_772 VPWR VGND sg13g2_decap_8
XFILLER_10_989 VPWR VGND sg13g2_decap_8
XFILLER_6_916 VPWR VGND sg13g2_decap_8
XFILLER_1_687 VPWR VGND sg13g2_decap_8
XFILLER_49_636 VPWR VGND sg13g2_fill_1
X_635_ _635_/Q _649_/CLK _635_/D fanout81/X VPWR VGND sg13g2_dfrbpq_1
X_566_ _566_/Q _629_/CLK _566_/D fanout68/X VPWR VGND sg13g2_dfrbpq_1
XFILLER_45_820 VPWR VGND sg13g2_decap_8
XFILLER_44_341 VPWR VGND sg13g2_fill_1
XFILLER_13_772 VPWR VGND sg13g2_decap_8
X_497_ _497_/Q _516_/CLK _497_/D fanout87/X VPWR VGND sg13g2_dfrbpq_1
XFILLER_9_765 VPWR VGND sg13g2_decap_8
XFILLER_5_960 VPWR VGND sg13g2_decap_8
XFILLER_36_820 VPWR VGND sg13g2_decap_8
X_420_ _585_/D _584_/Q _585_/Q _431_/S VPWR VGND sg13g2_mux2_1
X_351_ _516_/D _515_/Q _516_/Q _407_/S VPWR VGND sg13g2_mux2_1
XFILLER_42_801 VPWR VGND sg13g2_decap_8
XFILLER_10_786 VPWR VGND sg13g2_decap_8
X_282_ _282_/X _671_/Q _282_/B VPWR VGND sg13g2_and2_1
XFILLER_2_941 VPWR VGND sg13g2_decap_8
XFILLER_49_477 VPWR VGND sg13g2_fill_1
X_618_ _647_/D _649_/CLK _618_/D fanout81/X VPWR VGND sg13g2_dfrbpq_1
X_549_ _549_/Q _677_/CLK _549_/D fanout79/X VPWR VGND sg13g2_dfrbpq_1
XFILLER_33_801 VPWR VGND sg13g2_decap_8
XFILLER_3_738 VPWR VGND sg13g2_decap_8
X_403_ _568_/D _567_/Q _568_/Q _459_/S VPWR VGND sg13g2_mux2_1
X_334_ _501_/D _501_/Q _335_/B VPWR VGND sg13g2_xor2_1
XFILLER_30_804 VPWR VGND sg13g2_decap_8
X_265_ _283_/B _309_/A _307_/B VPWR VGND sg13g2_and2_1
XANTENNA_15 uio_in[3] VPWR VGND sg13g2_antennanp
XFILLER_47_756 VPWR VGND sg13g2_decap_8
XFILLER_11_870 VPWR VGND sg13g2_decap_8
Xinput13 _261_/A0 uio_in[3] VPWR VGND sg13g2_buf_1
X_317_ _317_/Y _254_/Y _286_/A _316_/Y VPWR VGND sg13g2_o21ai_1
X_248_ _248_/Y _500_/Q VPWR VGND sg13g2_inv_1
XFILLER_7_830 VPWR VGND sg13g2_decap_8
XFILLER_0_505 VPWR VGND sg13g2_decap_8
Xclkbuf_4_3_0_clk_regs clkbuf_4_3_0_clk_regs/X clkbuf_0_clk_regs/X VPWR VGND sg13g2_buf_8
XFILLER_4_855 VPWR VGND sg13g2_decap_8
XFILLER_3_321 VPWR VGND sg13g2_fill_1
XFILLER_8_20 VPWR VGND sg13g2_fill_1
XFILLER_33_0 VPWR VGND sg13g2_fill_1
XFILLER_0_357 VPWR VGND sg13g2_decap_8
XFILLER_1_869 VPWR VGND sg13g2_decap_8
XFILLER_49_807 VPWR VGND sg13g2_decap_8
X_582_ _582_/Q _586_/CLK _582_/D fanout96/X VPWR VGND sg13g2_dfrbpq_1
X_651_ _651_/Q _651_/CLK _651_/D fanout66/X VPWR VGND sg13g2_dfrbpq_1
XFILLER_13_954 VPWR VGND sg13g2_decap_8
XFILLER_9_947 VPWR VGND sg13g2_decap_8
XFILLER_3_162 VPWR VGND sg13g2_fill_1
XFILLER_10_968 VPWR VGND sg13g2_decap_8
XFILLER_5_449 VPWR VGND sg13g2_fill_1
XFILLER_1_666 VPWR VGND sg13g2_decap_8
X_634_ _634_/Q _647_/CLK _634_/D fanout84/X VPWR VGND sg13g2_dfrbpq_1
X_565_ _565_/Q _656_/CLK _565_/D fanout70/X VPWR VGND sg13g2_dfrbpq_1
X_496_ _684_/D _472_/Y _496_/D fanout75/X VPWR VGND sg13g2_dfrbpq_1
XFILLER_4_482 VPWR VGND sg13g2_decap_8
XFILLER_4_471 VPWR VGND sg13g2_fill_1
XFILLER_4_460 VPWR VGND sg13g2_decap_8
X_285__130 _675_/CLK _285__130/A VPWR VGND sg13g2_inv_1
XFILLER_2_419 VPWR VGND sg13g2_fill_1
XFILLER_27_821 VPWR VGND sg13g2_decap_8
X_350_ _515_/D _514_/Q _515_/Q _350_/S VPWR VGND sg13g2_mux2_1
XFILLER_10_765 VPWR VGND sg13g2_decap_8
X_281_ _281_/X _662_/Q _282_/B VPWR VGND sg13g2_and2_1
XFILLER_6_769 VPWR VGND sg13g2_fill_1
XFILLER_7_1002 VPWR VGND sg13g2_fill_2
XFILLER_2_997 VPWR VGND sg13g2_decap_8
XFILLER_2_920 VPWR VGND sg13g2_decap_8
XFILLER_18_821 VPWR VGND sg13g2_decap_8
X_617_ _617_/Q _656_/CLK _617_/D fanout70/X VPWR VGND sg13g2_dfrbpq_1
X_548_ _548_/Q _677_/CLK _548_/D fanout85/X VPWR VGND sg13g2_dfrbpq_1
X_479_ _479_/Y _488_/A _484_/B VPWR VGND sg13g2_xnor2_1
XFILLER_4_290 VPWR VGND sg13g2_fill_1
XFILLER_35_29 VPWR VGND sg13g2_fill_2
XFILLER_3_717 VPWR VGND sg13g2_decap_8
X_402_ _567_/D _566_/Q _567_/Q _459_/S VPWR VGND sg13g2_mux2_1
X_333_ _500_/D _248_/Y _329_/Y _335_/B VPWR VGND sg13g2_a21oi_1
X_264_ _489_/D _264_/A0 _685_/D _264_/S VPWR VGND sg13g2_mux2_1
XFILLER_1_260 VPWR VGND sg13g2_decap_4
XFILLER_2_794 VPWR VGND sg13g2_decap_8
XFILLER_12_849 VPWR VGND sg13g2_decap_8
XFILLER_4_1016 VPWR VGND sg13g2_decap_8
XFILLER_4_1027 VPWR VGND sg13g2_fill_2
X_316_ _316_/Y _316_/A1 _307_/Y _309_/Y _316_/B2 VPWR VGND sg13g2_a22oi_1
X_247_ _332_/A _498_/Q VPWR VGND sg13g2_inv_1
XFILLER_7_886 VPWR VGND sg13g2_decap_8
XFILLER_0_539 VPWR VGND sg13g2_decap_4
XFILLER_29_779 VPWR VGND sg13g2_decap_8
XFILLER_4_834 VPWR VGND sg13g2_decap_8
XFILLER_1_848 VPWR VGND sg13g2_decap_8
X_650_ _650_/Q _650_/CLK _650_/D fanout71/X VPWR VGND sg13g2_dfrbpq_1
XFILLER_13_933 VPWR VGND sg13g2_decap_8
X_581_ _581_/Q _586_/CLK _581_/D fanout96/X VPWR VGND sg13g2_dfrbpq_1
XFILLER_25_793 VPWR VGND sg13g2_decap_8
XFILLER_9_926 VPWR VGND sg13g2_decap_8
XFILLER_3_130 VPWR VGND sg13g2_fill_2
XFILLER_0_881 VPWR VGND sg13g2_decap_8
XFILLER_16_793 VPWR VGND sg13g2_decap_8
XFILLER_10_947 VPWR VGND sg13g2_decap_8
XFILLER_1_645 VPWR VGND sg13g2_decap_8
X_633_ _633_/Q _633_/CLK _633_/D fanout92/X VPWR VGND sg13g2_dfrbpq_1
X_564_ _564_/Q _650_/CLK _564_/D fanout70/X VPWR VGND sg13g2_dfrbpq_1
X_495_ _683_/D _471_/Y _495_/D fanout75/X VPWR VGND sg13g2_dfrbpq_1
XFILLER_5_995 VPWR VGND sg13g2_decap_8
XFILLER_27_800 VPWR VGND sg13g2_decap_8
X_280_ _280_/X _661_/Q _282_/B VPWR VGND sg13g2_and2_1
XFILLER_5_247 VPWR VGND sg13g2_fill_2
XFILLER_2_976 VPWR VGND sg13g2_decap_8
XFILLER_18_800 VPWR VGND sg13g2_decap_8
X_616_ _616_/Q _658_/CLK _616_/D fanout67/X VPWR VGND sg13g2_dfrbpq_1
X_547_ _547_/Q _560_/CLK _547_/D fanout79/X VPWR VGND sg13g2_dfrbpq_1
X_478_ _478_/Y _488_/A _478_/B VPWR VGND sg13g2_xnor2_1
XFILLER_5_792 VPWR VGND sg13g2_decap_8
XFILLER_24_814 VPWR VGND sg13g2_decap_8
Xclkbuf_0_clk_regs clkbuf_0_clk_regs/X clkbuf_regs_0_clk/X VPWR VGND sg13g2_buf_16
XFILLER_15_814 VPWR VGND sg13g2_decap_8
X_401_ _566_/D _565_/Q _566_/Q _459_/S VPWR VGND sg13g2_mux2_1
X_332_ _335_/B _332_/A _397_/S _332_/C VPWR VGND sg13g2_nor3_1
X_263_ _490_/D _263_/A0 _686_/D _264_/S VPWR VGND sg13g2_mux2_1
XFILLER_2_773 VPWR VGND sg13g2_decap_8
XFILLER_21_828 VPWR VGND sg13g2_decap_8
XFILLER_14_891 VPWR VGND sg13g2_fill_2
XFILLER_12_828 VPWR VGND sg13g2_decap_8
Xdelaybuf_1_clk delaybuf_2_clk/A _284_/B VPWR VGND sg13g2_buf_16
X_315_ _315_/Y _253_/Y _286_/A _314_/Y VPWR VGND sg13g2_o21ai_1
X_246_ _246_/Y _497_/Q VPWR VGND sg13g2_inv_1
XFILLER_7_865 VPWR VGND sg13g2_decap_8
XFILLER_4_813 VPWR VGND sg13g2_decap_8
XFILLER_43_794 VPWR VGND sg13g2_decap_8
XFILLER_1_827 VPWR VGND sg13g2_decap_8
XFILLER_1_1009 VPWR VGND sg13g2_decap_8
X_580_ _580_/Q _580_/CLK _580_/D fanout96/X VPWR VGND sg13g2_dfrbpq_1
XFILLER_13_912 VPWR VGND sg13g2_decap_8
XFILLER_9_905 VPWR VGND sg13g2_decap_8
XFILLER_25_772 VPWR VGND sg13g2_decap_8
XFILLER_13_989 VPWR VGND sg13g2_decap_8
XFILLER_40_797 VPWR VGND sg13g2_decap_8
XFILLER_0_860 VPWR VGND sg13g2_decap_8
XFILLER_16_772 VPWR VGND sg13g2_decap_8
XFILLER_8_982 VPWR VGND sg13g2_decap_8
XFILLER_10_926 VPWR VGND sg13g2_decap_8
XFILLER_22_786 VPWR VGND sg13g2_decap_8
XFILLER_1_624 VPWR VGND sg13g2_decap_8
X_632_ _632_/Q _688_/CLK _632_/D fanout74/X VPWR VGND sg13g2_dfrbpq_1
X_563_ _563_/Q _686_/CLK _563_/D fanout79/X VPWR VGND sg13g2_dfrbpq_1
XFILLER_45_834 VPWR VGND sg13g2_fill_1
XFILLER_13_786 VPWR VGND sg13g2_decap_8
X_494_ _682_/D _470_/Y _494_/D fanout75/X VPWR VGND sg13g2_dfrbpq_1
XFILLER_9_779 VPWR VGND sg13g2_decap_8
XFILLER_5_974 VPWR VGND sg13g2_decap_8
XFILLER_5_89 VPWR VGND sg13g2_fill_2
XFILLER_46_609 VPWR VGND sg13g2_fill_1
XFILLER_42_815 VPWR VGND sg13g2_decap_8
XFILLER_5_259 VPWR VGND sg13g2_fill_1
XFILLER_2_955 VPWR VGND sg13g2_decap_8
X_615_ _615_/Q _655_/CLK _615_/D fanout65/X VPWR VGND sg13g2_dfrbpq_1
X_546_ _546_/Q _560_/CLK _546_/D fanout78/X VPWR VGND sg13g2_dfrbpq_1
XFILLER_33_815 VPWR VGND sg13g2_decap_8
Xu_multimode_dll VPWR VGND _542_/Q _316_/A1 _524_/Q _525_/Q _526_/Q _527_/Q _528_/Q
+ _314_/A1 _529_/Q _530_/Q _531_/Q _532_/Q _533_/Q _312_/A1 _534_/Q _535_/Q _536_/Q
+ _537_/Q _538_/Q _543_/Q ena _544_/Q _554_/Q _555_/Q _556_/Q _557_/Q _558_/Q _559_/Q
+ _560_/Q _561_/Q _562_/Q _563_/Q _545_/Q _564_/Q _565_/Q _566_/Q _567_/Q _568_/Q
+ _569_/Q _546_/Q _547_/Q _548_/Q _549_/Q _550_/Q _551_/Q _552_/Q _553_/Q _509_/Q
+ _510_/Q _511_/Q _512_/Q _513_/Q _514_/Q _515_/Q _516_/Q _517_/Q _518_/Q _519_/Q
+ _520_/Q _521_/Q _522_/Q _523_/Q _504_/Q _505_/Q _506_/Q _507_/Q _508_/Q _539_/Q
+ _540_/Q _541_/Q delaybuf_15_clk/X _310_/A1 fanout82/X _308_/A0 multimode_dll
X_477_ _477_/Y _488_/A _484_/B VPWR VGND sg13g2_xnor2_1
X_400_ _565_/D _564_/Q _565_/Q _457_/S VPWR VGND sg13g2_mux2_1
X_331_ _332_/C _497_/Q _499_/Q _500_/Q VPWR VGND sg13g2_nand3_1
X_262_ _491_/D _262_/A0 _687_/D _264_/S VPWR VGND sg13g2_mux2_1
XFILLER_41_30 VPWR VGND sg13g2_fill_1
XFILLER_30_818 VPWR VGND sg13g2_decap_8
XFILLER_2_752 VPWR VGND sg13g2_decap_8
XFILLER_2_46 VPWR VGND sg13g2_fill_1
XFILLER_14_870 VPWR VGND sg13g2_decap_8
X_529_ _529_/Q _539_/CLK _529_/D fanout90/X VPWR VGND sg13g2_dfrbpq_1
XFILLER_21_807 VPWR VGND sg13g2_decap_8
XFILLER_12_807 VPWR VGND sg13g2_decap_8
XFILLER_3_538 VPWR VGND sg13g2_decap_4
XFILLER_3_516 VPWR VGND sg13g2_decap_4
X_314_ _314_/Y _314_/A1 _307_/Y _309_/Y _314_/B2 VPWR VGND sg13g2_a22oi_1
XFILLER_11_884 VPWR VGND sg13g2_decap_8
XFILLER_7_844 VPWR VGND sg13g2_decap_8
XFILLER_46_781 VPWR VGND sg13g2_decap_8
XFILLER_0_519 VPWR VGND sg13g2_fill_2
XFILLER_4_869 VPWR VGND sg13g2_decap_8
XFILLER_1_806 VPWR VGND sg13g2_decap_8
XFILLER_17_10 VPWR VGND sg13g2_fill_2
XFILLER_17_54 VPWR VGND sg13g2_fill_2
XFILLER_13_968 VPWR VGND sg13g2_decap_8
XFILLER_3_132 VPWR VGND sg13g2_fill_1
Xclkbuf_4_2_0_clk_regs clkbuf_4_2_0_clk_regs/X clkbuf_0_clk_regs/X VPWR VGND sg13g2_buf_8
XFILLER_8_961 VPWR VGND sg13g2_decap_8
XFILLER_31_0 VPWR VGND sg13g2_fill_2
XFILLER_39_821 VPWR VGND sg13g2_decap_4
XFILLER_0_1021 VPWR VGND sg13g2_decap_8
XFILLER_10_905 VPWR VGND sg13g2_decap_8
XFILLER_22_765 VPWR VGND sg13g2_decap_8
XFILLER_6_909 VPWR VGND sg13g2_decap_8
X_631_ _631_/Q _684_/CLK _631_/D fanout74/X VPWR VGND sg13g2_dfrbpq_1
X_562_ _562_/Q _677_/CLK _562_/D fanout85/X VPWR VGND sg13g2_dfrbpq_1
X_493_ _681_/D _469_/Y _493_/D fanout75/X VPWR VGND sg13g2_dfrbpq_1
XFILLER_45_813 VPWR VGND sg13g2_decap_8
XFILLER_13_765 VPWR VGND sg13g2_decap_8
XFILLER_5_953 VPWR VGND sg13g2_decap_8
XFILLER_36_813 VPWR VGND sg13g2_decap_8
XFILLER_10_779 VPWR VGND sg13g2_decap_8
XFILLER_2_934 VPWR VGND sg13g2_decap_8
X_614_ _614_/Q _655_/CLK _614_/D fanout65/X VPWR VGND sg13g2_dfrbpq_1
X_545_ _545_/Q _686_/CLK _545_/D fanout78/X VPWR VGND sg13g2_dfrbpq_1
X_476_ _476_/Y _488_/A _487_/B VPWR VGND sg13g2_xnor2_1
XFILLER_44_186 VPWR VGND sg13g2_fill_1
Xdelaybuf_20_clk delaybuf_21_clk/A delaybuf_20_clk/A VPWR VGND sg13g2_buf_16
Xdelaybuf_11_clk delaybuf_12_clk/A delaybuf_11_clk/A VPWR VGND sg13g2_buf_16
X_330_ _499_/D _499_/Q _330_/B VPWR VGND sg13g2_xnor2_1
X_261_ _492_/D _261_/A0 _688_/D _264_/S VPWR VGND sg13g2_mux2_1
XFILLER_9_0 VPWR VGND sg13g2_fill_2
XFILLER_2_731 VPWR VGND sg13g2_decap_8
XFILLER_14_893 VPWR VGND sg13g2_fill_1
X_528_ _528_/Q _647_/CLK _528_/D fanout83/X VPWR VGND sg13g2_dfrbpq_1
X_459_ _624_/D _652_/D _653_/D _459_/S VPWR VGND sg13g2_mux2_1
XFILLER_12_1010 VPWR VGND sg13g2_decap_8
XFILLER_12_1021 VPWR VGND sg13g2_fill_2
XFILLER_5_580 VPWR VGND sg13g2_decap_8
Xclkbuf_4_15_0_clk_regs clkbuf_4_15_0_clk_regs/X clkbuf_0_clk_regs/X VPWR VGND sg13g2_buf_8
X_313_ _313_/Y _252_/Y _286_/A _312_/Y VPWR VGND sg13g2_o21ai_1
XFILLER_11_863 VPWR VGND sg13g2_decap_8
XFILLER_7_823 VPWR VGND sg13g2_decap_8
XFILLER_46_760 VPWR VGND sg13g2_decap_8
XFILLER_4_848 VPWR VGND sg13g2_decap_8
XFILLER_28_793 VPWR VGND sg13g2_decap_8
XFILLER_3_892 VPWR VGND sg13g2_decap_8
XFILLER_19_793 VPWR VGND sg13g2_decap_8
XFILLER_34_796 VPWR VGND sg13g2_decap_8
XFILLER_44_527 VPWR VGND sg13g2_fill_1
XFILLER_13_947 VPWR VGND sg13g2_decap_8
XFILLER_0_895 VPWR VGND sg13g2_decap_8
XFILLER_48_822 VPWR VGND sg13g2_decap_8
XFILLER_8_940 VPWR VGND sg13g2_decap_8
XFILLER_39_800 VPWR VGND sg13g2_decap_8
XFILLER_0_1000 VPWR VGND sg13g2_decap_8
XFILLER_1_659 VPWR VGND sg13g2_decap_8
X_630_ _630_/Q _685_/CLK _630_/D fanout85/X VPWR VGND sg13g2_dfrbpq_1
Xclkbuf_1_1__f_clk clkload0/A clkbuf_0_clk/X VPWR VGND sg13g2_buf_16
X_561_ _561_/Q _685_/CLK _561_/D fanout85/X VPWR VGND sg13g2_dfrbpq_1
X_492_ _688_/D _468_/Y _492_/D fanout77/X VPWR VGND sg13g2_dfrbpq_1
XFILLER_5_932 VPWR VGND sg13g2_decap_8
XFILLER_5_47 VPWR VGND sg13g2_fill_2
XFILLER_0_692 VPWR VGND sg13g2_decap_8
XFILLER_27_814 VPWR VGND sg13g2_decap_8
XFILLER_2_913 VPWR VGND sg13g2_decap_8
XFILLER_18_814 VPWR VGND sg13g2_decap_8
X_613_ _640_/D _653_/CLK _613_/D fanout73/X VPWR VGND sg13g2_dfrbpq_1
X_544_ _544_/Q _688_/CLK _544_/D fanout77/X VPWR VGND sg13g2_dfrbpq_1
X_475_ _475_/Y _488_/A _487_/B VPWR VGND sg13g2_xnor2_1
XFILLER_4_272 VPWR VGND sg13g2_decap_8
XFILLER_4_261 VPWR VGND sg13g2_fill_1
XFILLER_24_828 VPWR VGND sg13g2_decap_8
XFILLER_15_828 VPWR VGND sg13g2_decap_8
X_260_ _264_/S _675_/Q _676_/Q VPWR VGND sg13g2_nand2b_1
Xdelaybuf_4_clk delaybuf_5_clk/A delaybuf_4_clk/A VPWR VGND sg13g2_buf_16
XFILLER_2_787 VPWR VGND sg13g2_decap_8
XFILLER_2_710 VPWR VGND sg13g2_decap_8
X_527_ _527_/Q _539_/CLK _527_/D fanout90/X VPWR VGND sg13g2_dfrbpq_1
XFILLER_45_474 VPWR VGND sg13g2_fill_1
X_458_ _623_/D _651_/D _652_/D _464_/S VPWR VGND sg13g2_mux2_1
X_389_ _554_/D _553_/Q _554_/Q _459_/S VPWR VGND sg13g2_mux2_1
Xclkbuf_1_0__f__017__regs _285__130/A clkbuf_0__017__regs/X VPWR VGND sg13g2_buf_16
XFILLER_5_592 VPWR VGND sg13g2_decap_8
XFILLER_4_1009 VPWR VGND sg13g2_decap_8
XFILLER_11_842 VPWR VGND sg13g2_decap_8
X_312_ _312_/Y _312_/A1 _307_/Y _309_/Y _312_/B2 VPWR VGND sg13g2_a22oi_1
XFILLER_7_802 VPWR VGND sg13g2_decap_8
XFILLER_7_879 VPWR VGND sg13g2_decap_8
XFILLER_4_827 VPWR VGND sg13g2_decap_8
XFILLER_28_772 VPWR VGND sg13g2_decap_8
XFILLER_3_871 VPWR VGND sg13g2_decap_8
XFILLER_19_772 VPWR VGND sg13g2_decap_8
XFILLER_13_926 VPWR VGND sg13g2_decap_8
XFILLER_25_786 VPWR VGND sg13g2_decap_8
XFILLER_9_919 VPWR VGND sg13g2_decap_8
XFILLER_0_874 VPWR VGND sg13g2_decap_8
XFILLER_48_801 VPWR VGND sg13g2_decap_8
XFILLER_16_786 VPWR VGND sg13g2_decap_8
XFILLER_8_996 VPWR VGND sg13g2_decap_8
XFILLER_1_638 VPWR VGND sg13g2_decap_8
X_560_ _560_/Q _560_/CLK _560_/D fanout79/X VPWR VGND sg13g2_dfrbpq_1
XFILLER_28_55 VPWR VGND sg13g2_fill_1
X_491_ _687_/D _467_/Y _491_/D fanout77/X VPWR VGND sg13g2_dfrbpq_1
XFILLER_44_65 VPWR VGND sg13g2_fill_2
XFILLER_5_911 VPWR VGND sg13g2_decap_8
XFILLER_0_671 VPWR VGND sg13g2_decap_8
XFILLER_5_988 VPWR VGND sg13g2_decap_8
XFILLER_47_174 VPWR VGND sg13g2_fill_1
XFILLER_42_829 VPWR VGND sg13g2_decap_4
XFILLER_2_969 VPWR VGND sg13g2_decap_8
X_612_ _612_/Q _653_/CLK _612_/D fanout73/X VPWR VGND sg13g2_dfrbpq_1
X_543_ _543_/Q _570_/CLK _543_/D fanout88/X VPWR VGND sg13g2_dfrbpq_1
XFILLER_33_829 VPWR VGND sg13g2_decap_4
X_474_ _474_/Y _488_/A _487_/B VPWR VGND sg13g2_xnor2_1
XFILLER_5_785 VPWR VGND sg13g2_decap_8
XFILLER_5_763 VPWR VGND sg13g2_decap_4
XFILLER_24_807 VPWR VGND sg13g2_decap_8
XFILLER_15_807 VPWR VGND sg13g2_decap_8
XFILLER_9_2 VPWR VGND sg13g2_fill_1
XFILLER_2_766 VPWR VGND sg13g2_decap_8
X_526_ _526_/Q _633_/CLK _526_/D fanout92/X VPWR VGND sg13g2_dfrbpq_1
XFILLER_14_884 VPWR VGND sg13g2_decap_8
X_457_ _622_/D _621_/Q _651_/D _457_/S VPWR VGND sg13g2_mux2_1
X_388_ _553_/D _552_/Q _553_/Q _459_/S VPWR VGND sg13g2_mux2_1
XFILLER_20_821 VPWR VGND sg13g2_decap_8
XFILLER_11_36 VPWR VGND sg13g2_fill_1
XFILLER_36_55 VPWR VGND sg13g2_fill_1
XFILLER_11_821 VPWR VGND sg13g2_decap_8
XFILLER_11_898 VPWR VGND sg13g2_decap_8
X_311_ _311_/Y _251_/Y _286_/A _310_/Y VPWR VGND sg13g2_o21ai_1
XFILLER_7_858 VPWR VGND sg13g2_decap_8
XFILLER_2_563 VPWR VGND sg13g2_fill_2
X_509_ _509_/Q _573_/CLK _509_/D fanout94/X VPWR VGND sg13g2_dfrbpq_1
XFILLER_46_795 VPWR VGND sg13g2_decap_8
XFILLER_3_70 VPWR VGND sg13g2_fill_1
XFILLER_4_806 VPWR VGND sg13g2_decap_8
XFILLER_3_349 VPWR VGND sg13g2_fill_1
XFILLER_43_787 VPWR VGND sg13g2_decap_8
XFILLER_43_765 VPWR VGND sg13g2_fill_1
XFILLER_3_850 VPWR VGND sg13g2_decap_8
XFILLER_2_393 VPWR VGND sg13g2_fill_2
XFILLER_13_905 VPWR VGND sg13g2_decap_8
XFILLER_25_765 VPWR VGND sg13g2_decap_8
XFILLER_0_853 VPWR VGND sg13g2_decap_8
XFILLER_12_982 VPWR VGND sg13g2_decap_8
XFILLER_16_765 VPWR VGND sg13g2_decap_8
XFILLER_31_768 VPWR VGND sg13g2_decap_8
XFILLER_8_975 VPWR VGND sg13g2_decap_8
XFILLER_10_919 VPWR VGND sg13g2_decap_8
XFILLER_30_790 VPWR VGND sg13g2_decap_8
XFILLER_22_779 VPWR VGND sg13g2_decap_8
XFILLER_0_149 VPWR VGND sg13g2_fill_2
XFILLER_1_617 VPWR VGND sg13g2_decap_8
XFILLER_45_827 VPWR VGND sg13g2_decap_8
XFILLER_13_779 VPWR VGND sg13g2_decap_8
X_490_ _686_/D _466_/Y _490_/D fanout77/X VPWR VGND sg13g2_dfrbpq_1
XFILLER_5_967 VPWR VGND sg13g2_decap_8
XFILLER_0_650 VPWR VGND sg13g2_decap_8
X_688_ _688_/Q _688_/CLK _688_/D fanout78/X VPWR VGND sg13g2_dfrbpq_1
XFILLER_36_827 VPWR VGND sg13g2_decap_4
XFILLER_8_772 VPWR VGND sg13g2_fill_1
Xdelaybuf_23_clk delaybuf_24_clk/A clk VPWR VGND sg13g2_buf_16
XFILLER_42_808 VPWR VGND sg13g2_decap_8
Xclkbuf_4_1_0_clk_regs clkbuf_4_1_0_clk_regs/X clkbuf_0_clk_regs/X VPWR VGND sg13g2_buf_8
Xdelaybuf_14_clk delaybuf_14_clk/X delaybuf_14_clk/A VPWR VGND sg13g2_buf_16
XFILLER_2_948 VPWR VGND sg13g2_decap_8
X_611_ _638_/D _651_/CLK _611_/D fanout66/X VPWR VGND sg13g2_dfrbpq_1
X_542_ _542_/Q _542_/CLK _542_/D fanout84/X VPWR VGND sg13g2_dfrbpq_1
X_473_ _473_/Y _488_/A _478_/B VPWR VGND sg13g2_xnor2_1
XFILLER_33_808 VPWR VGND sg13g2_decap_8
XFILLER_5_742 VPWR VGND sg13g2_decap_8
XFILLER_1_981 VPWR VGND sg13g2_decap_8
XFILLER_2_745 VPWR VGND sg13g2_decap_8
XFILLER_14_863 VPWR VGND sg13g2_decap_8
X_525_ _525_/Q _525_/CLK _525_/D fanout91/X VPWR VGND sg13g2_dfrbpq_1
X_456_ _621_/D _620_/Q _621_/Q _456_/S VPWR VGND sg13g2_mux2_1
X_387_ _552_/D _551_/Q _552_/Q _463_/S VPWR VGND sg13g2_mux2_1
XFILLER_49_793 VPWR VGND sg13g2_decap_8
XFILLER_20_800 VPWR VGND sg13g2_decap_8
XFILLER_11_800 VPWR VGND sg13g2_decap_8
X_310_ _310_/Y _310_/A1 _307_/Y _309_/Y _310_/B2 VPWR VGND sg13g2_a22oi_1
XFILLER_11_877 VPWR VGND sg13g2_decap_8
XFILLER_7_837 VPWR VGND sg13g2_decap_8
XFILLER_46_774 VPWR VGND sg13g2_decap_8
X_508_ _508_/Q _570_/CLK _508_/D fanout87/X VPWR VGND sg13g2_dfrbpq_1
X_439_ _604_/D _603_/Q _604_/Q _439_/S VPWR VGND sg13g2_mux2_1
XFILLER_6_881 VPWR VGND sg13g2_decap_8
XFILLER_3_1011 VPWR VGND sg13g2_decap_8
Xclkbuf_4_14_0_clk_regs clkbuf_4_14_0_clk_regs/X clkbuf_0_clk_regs/X VPWR VGND sg13g2_buf_8
XFILLER_40_769 VPWR VGND sg13g2_fill_1
XFILLER_3_114 VPWR VGND sg13g2_fill_2
XFILLER_0_832 VPWR VGND sg13g2_decap_8
XFILLER_12_961 VPWR VGND sg13g2_decap_8
XFILLER_8_954 VPWR VGND sg13g2_decap_8
Xclkbuf_leaf_2_clk _472_/B delaybuf_14_clk/X VPWR VGND sg13g2_buf_8
XFILLER_39_825 VPWR VGND sg13g2_fill_2
XFILLER_39_814 VPWR VGND sg13g2_decap_8
XFILLER_0_1014 VPWR VGND sg13g2_decap_8
XFILLER_0_72 VPWR VGND sg13g2_fill_2
XFILLER_45_806 VPWR VGND sg13g2_decap_8
XFILLER_5_946 VPWR VGND sg13g2_decap_8
XFILLER_4_489 VPWR VGND sg13g2_fill_2
XFILLER_4_467 VPWR VGND sg13g2_decap_4
XFILLER_36_806 VPWR VGND sg13g2_decap_8
X_687_ _687_/Q _688_/CLK _687_/D fanout78/X VPWR VGND sg13g2_dfrbpq_1
XFILLER_27_828 VPWR VGND sg13g2_decap_8
Xu_custom_cells.u_final_mux.SwitchMatrixMultiplexer_inv_inst _605_/Q _312_/B2 VPWR
+ _316_/B2 _308_/A1 VGND _603_/Q SwitchMatrixMultiplexer_inv
XFILLER_2_927 VPWR VGND sg13g2_decap_8
X_610_ _637_/D _656_/CLK _610_/D fanout70/X VPWR VGND sg13g2_dfrbpq_1
XFILLER_18_828 VPWR VGND sg13g2_decap_8
X_541_ _541_/Q _542_/CLK _541_/D fanout90/X VPWR VGND sg13g2_dfrbpq_1
X_472_ _472_/Y _488_/A _472_/B VPWR VGND sg13g2_xnor2_1
Xdelaybuf_7_clk _488_/B delaybuf_7_clk/A VPWR VGND sg13g2_buf_16
XFILLER_5_721 VPWR VGND sg13g2_decap_8
XFILLER_1_960 VPWR VGND sg13g2_decap_8
XFILLER_0_492 VPWR VGND sg13g2_fill_2
Xu_custom_cells.u_mux1.mux_inv_inst _314_/B2 VPWR VGND _602_/Q _601_/Q _600_/Q mux_inv
XFILLER_1_201 VPWR VGND sg13g2_fill_1
XFILLER_2_724 VPWR VGND sg13g2_decap_8
XFILLER_14_842 VPWR VGND sg13g2_decap_8
X_524_ _524_/Q _525_/CLK _524_/D fanout91/X VPWR VGND sg13g2_dfrbpq_1
X_455_ _620_/D _619_/Q _620_/Q _455_/S VPWR VGND sg13g2_mux2_1
X_386_ _551_/D _550_/Q _551_/Q _463_/S VPWR VGND sg13g2_mux2_1
XFILLER_12_1003 VPWR VGND sg13g2_decap_8
XFILLER_5_573 VPWR VGND sg13g2_decap_8
XFILLER_49_772 VPWR VGND sg13g2_decap_8
XFILLER_11_856 VPWR VGND sg13g2_decap_8
XFILLER_7_816 VPWR VGND sg13g2_decap_8
XFILLER_2_565 VPWR VGND sg13g2_fill_1
X_507_ _507_/Q _516_/CLK _507_/D fanout87/X VPWR VGND sg13g2_dfrbpq_1
X_438_ _603_/D _602_/Q _603_/Q _442_/S VPWR VGND sg13g2_mux2_1
X_369_ _534_/D _533_/Q _534_/Q _455_/S VPWR VGND sg13g2_mux2_1
XFILLER_6_860 VPWR VGND sg13g2_decap_8
XFILLER_47_517 VPWR VGND sg13g2_fill_2
XFILLER_28_786 VPWR VGND sg13g2_decap_8
XFILLER_3_885 VPWR VGND sg13g2_decap_8
XFILLER_19_786 VPWR VGND sg13g2_decap_8
XFILLER_46_550 VPWR VGND sg13g2_fill_2
XFILLER_0_811 VPWR VGND sg13g2_decap_8
XFILLER_0_888 VPWR VGND sg13g2_decap_8
Xu_clkbuf_analog_pin2.u_buf analog_pin2 _488_/A VPWR VGND sg13g2_buf_16
XFILLER_48_815 VPWR VGND sg13g2_decap_8
XFILLER_12_940 VPWR VGND sg13g2_decap_8
XFILLER_8_933 VPWR VGND sg13g2_decap_8
XFILLER_3_682 VPWR VGND sg13g2_decap_8
XFILLER_5_925 VPWR VGND sg13g2_decap_8
XFILLER_0_685 VPWR VGND sg13g2_decap_8
X_686_ _686_/Q _686_/CLK _686_/D fanout77/X VPWR VGND sg13g2_dfrbpq_1
XFILLER_15_0 VPWR VGND sg13g2_fill_1
XFILLER_27_807 VPWR VGND sg13g2_decap_8
Xu_custom_cells.u_latch0.latch_inst _312_/B2 _310_/B2 VGND VPWR _605_/Q latch
XFILLER_2_906 VPWR VGND sg13g2_decap_8
XFILLER_18_807 VPWR VGND sg13g2_decap_8
X_540_ _540_/Q _542_/CLK _540_/D fanout90/X VPWR VGND sg13g2_dfrbpq_1
X_471_ _471_/Y _488_/A _472_/B VPWR VGND sg13g2_xnor2_1
XFILLER_44_147 VPWR VGND sg13g2_fill_2
XFILLER_4_210 VPWR VGND sg13g2_decap_4
XFILLER_5_799 VPWR VGND sg13g2_decap_8
XFILLER_4_265 VPWR VGND sg13g2_decap_8
X_669_ _669_/Q _483_/Y _669_/D fanout81/X VPWR VGND sg13g2_dfrbpq_1
XFILLER_6_1021 VPWR VGND sg13g2_decap_8
XFILLER_23_821 VPWR VGND sg13g2_decap_8
XFILLER_2_703 VPWR VGND sg13g2_decap_8
X_523_ _523_/Q _525_/CLK _523_/D fanout91/X VPWR VGND sg13g2_dfrbpq_1
XFILLER_14_821 VPWR VGND sg13g2_decap_8
XFILLER_14_898 VPWR VGND sg13g2_decap_8
X_454_ _619_/D _647_/D _619_/Q _456_/S VPWR VGND sg13g2_mux2_1
X_385_ _550_/D _549_/Q _550_/Q _398_/S VPWR VGND sg13g2_mux2_1
XFILLER_5_552 VPWR VGND sg13g2_decap_8
XFILLER_49_751 VPWR VGND sg13g2_decap_8
XFILLER_9_891 VPWR VGND sg13g2_decap_8
XFILLER_46_209 VPWR VGND sg13g2_fill_1
XFILLER_11_835 VPWR VGND sg13g2_decap_8
XFILLER_2_500 VPWR VGND sg13g2_fill_1
X_506_ _506_/Q _516_/CLK _506_/D fanout86/X VPWR VGND sg13g2_dfrbpq_1
XFILLER_45_264 VPWR VGND sg13g2_fill_1
X_437_ _602_/D _601_/Q _602_/Q _442_/S VPWR VGND sg13g2_mux2_1
X_368_ _533_/D _532_/Q _533_/Q _455_/S VPWR VGND sg13g2_mux2_1
X_299_ _663_/D _641_/Q _655_/Q _303_/S VPWR VGND sg13g2_mux2_1
XFILLER_3_319 VPWR VGND sg13g2_fill_2
XFILLER_22_27 VPWR VGND sg13g2_fill_2
Xfanout100 fanout99/A input1/X VPWR VGND sg13g2_buf_1
XFILLER_28_765 VPWR VGND sg13g2_decap_8
XFILLER_8_18 VPWR VGND sg13g2_fill_2
XFILLER_3_864 VPWR VGND sg13g2_decap_8
XFILLER_19_765 VPWR VGND sg13g2_decap_8
XFILLER_13_919 VPWR VGND sg13g2_decap_8
XFILLER_25_779 VPWR VGND sg13g2_decap_8
XFILLER_3_116 VPWR VGND sg13g2_fill_1
XFILLER_0_867 VPWR VGND sg13g2_decap_8
XFILLER_16_779 VPWR VGND sg13g2_decap_8
XFILLER_12_996 VPWR VGND sg13g2_decap_8
XFILLER_8_989 VPWR VGND sg13g2_decap_8
XFILLER_8_912 VPWR VGND sg13g2_decap_8
XFILLER_0_74 VPWR VGND sg13g2_fill_1
XFILLER_9_50 VPWR VGND sg13g2_fill_1
Xdelaybuf_26_clk delaybuf_27_clk/A delaybuf_26_clk/A VPWR VGND sg13g2_buf_16
XFILLER_5_904 VPWR VGND sg13g2_decap_8
XFILLER_21_793 VPWR VGND sg13g2_decap_8
XFILLER_0_664 VPWR VGND sg13g2_decap_8
Xdelaybuf_17_clk delaybuf_18_clk/A delaybuf_17_clk/A VPWR VGND sg13g2_buf_16
X_685_ _685_/Q _685_/CLK _685_/D fanout85/X VPWR VGND sg13g2_dfrbpq_1
XFILLER_48_624 VPWR VGND sg13g2_fill_2
XFILLER_47_123 VPWR VGND sg13g2_fill_1
XFILLER_12_793 VPWR VGND sg13g2_decap_8
XFILLER_4_981 VPWR VGND sg13g2_decap_8
Xu_clkbuf_analog_pin1.u_buf analog_pin1 _314_/A1 VPWR VGND sg13g2_buf_16
XFILLER_30_27 VPWR VGND sg13g2_fill_2
XFILLER_26_830 VPWR VGND sg13g2_fill_1
X_470_ _470_/Y _488_/A _472_/B VPWR VGND sg13g2_xnor2_1
XFILLER_41_833 VPWR VGND sg13g2_fill_2
XFILLER_5_778 VPWR VGND sg13g2_decap_8
XFILLER_5_767 VPWR VGND sg13g2_fill_1
XFILLER_5_756 VPWR VGND sg13g2_decap_8
XFILLER_0_494 VPWR VGND sg13g2_fill_1
XFILLER_1_995 VPWR VGND sg13g2_decap_8
X_599_ _599_/Q _601_/CLK _599_/D fanout99/X VPWR VGND sg13g2_dfrbpq_1
X_668_ _668_/Q _482_/Y _668_/D fanout83/X VPWR VGND sg13g2_dfrbpq_1
XFILLER_32_811 VPWR VGND sg13g2_decap_8
XFILLER_6_1000 VPWR VGND sg13g2_decap_8
XFILLER_23_800 VPWR VGND sg13g2_decap_8
XFILLER_2_759 VPWR VGND sg13g2_decap_8
XFILLER_14_800 VPWR VGND sg13g2_decap_8
X_522_ _522_/Q _525_/CLK _522_/D fanout91/X VPWR VGND sg13g2_dfrbpq_1
X_453_ _618_/D _617_/Q _647_/D _456_/S VPWR VGND sg13g2_mux2_1
XFILLER_12_1027 VPWR VGND sg13g2_fill_2
XFILLER_14_877 VPWR VGND sg13g2_decap_8
X_384_ _549_/D _548_/Q _549_/Q _397_/S VPWR VGND sg13g2_mux2_1
XFILLER_1_792 VPWR VGND sg13g2_decap_8
XFILLER_20_814 VPWR VGND sg13g2_decap_8
Xclkbuf_4_0_0_clk_regs clkbuf_4_0_0_clk_regs/X clkbuf_0_clk_regs/X VPWR VGND sg13g2_buf_8
XFILLER_9_870 VPWR VGND sg13g2_decap_8
XFILLER_11_814 VPWR VGND sg13g2_decap_8
XFILLER_2_556 VPWR VGND sg13g2_decap_8
X_505_ _505_/Q _573_/CLK _505_/D fanout86/X VPWR VGND sg13g2_dfrbpq_1
X_436_ _601_/D _600_/Q _601_/Q _442_/S VPWR VGND sg13g2_mux2_1
XFILLER_46_788 VPWR VGND sg13g2_decap_8
XFILLER_10_891 VPWR VGND sg13g2_decap_8
X_367_ _532_/D _531_/Q _532_/Q _455_/S VPWR VGND sg13g2_mux2_1
X_298_ _670_/D _636_/Q _650_/Q _306_/S VPWR VGND sg13g2_mux2_1
XFILLER_6_895 VPWR VGND sg13g2_decap_8
XFILLER_5_372 VPWR VGND sg13g2_decap_4
XFILLER_3_85 VPWR VGND sg13g2_fill_2
XFILLER_3_1025 VPWR VGND sg13g2_decap_4
XFILLER_5_0 VPWR VGND sg13g2_fill_1
XFILLER_3_843 VPWR VGND sg13g2_decap_8
XFILLER_2_386 VPWR VGND sg13g2_decap_8
X_419_ _584_/D _583_/Q _584_/Q _419_/S VPWR VGND sg13g2_mux2_1
Xclkbuf_leaf_5_clk _484_/B clkbuf_leaf_6_clk/A VPWR VGND sg13g2_buf_8
Xclkbuf_5_19__f_clk_regs _539_/CLK clkbuf_4_9_0_clk_regs/X VPWR VGND sg13g2_buf_16
XFILLER_0_846 VPWR VGND sg13g2_decap_8
XFILLER_12_975 VPWR VGND sg13g2_decap_8
XFILLER_8_968 VPWR VGND sg13g2_decap_8
XFILLER_0_1028 VPWR VGND sg13g2_fill_1
XFILLER_30_783 VPWR VGND sg13g2_decap_8
XFILLER_30_772 VPWR VGND sg13g2_fill_1
XFILLER_21_772 VPWR VGND sg13g2_decap_8
XFILLER_4_448 VPWR VGND sg13g2_decap_4
XFILLER_4_404 VPWR VGND sg13g2_fill_2
XFILLER_0_643 VPWR VGND sg13g2_decap_8
Xclkbuf_4_13_0_clk_regs clkbuf_4_13_0_clk_regs/X clkbuf_0_clk_regs/X VPWR VGND sg13g2_buf_8
X_684_ _684_/Q _684_/CLK _684_/D fanout75/X VPWR VGND sg13g2_dfrbpq_1
X_285__129 _676_/CLK _285__130/A VPWR VGND sg13g2_inv_1
XFILLER_12_772 VPWR VGND sg13g2_decap_8
XFILLER_8_765 VPWR VGND sg13g2_decap_8
XFILLER_4_960 VPWR VGND sg13g2_decap_8
XFILLER_35_820 VPWR VGND sg13g2_decap_8
XFILLER_41_812 VPWR VGND sg13g2_decap_8
XFILLER_5_735 VPWR VGND sg13g2_decap_8
XFILLER_1_974 VPWR VGND sg13g2_decap_8
X_598_ _598_/Q _601_/CLK _598_/D fanout99/X VPWR VGND sg13g2_dfrbpq_1
X_667_ _667_/Q _481_/Y _667_/D fanout83/X VPWR VGND sg13g2_dfrbpq_1
XFILLER_45_80 VPWR VGND sg13g2_fill_1
XANTENNA_1 _542_/Q VPWR VGND sg13g2_antennanp
XFILLER_2_738 VPWR VGND sg13g2_decap_8
XFILLER_14_856 VPWR VGND sg13g2_decap_8
X_521_ _521_/Q _633_/CLK _521_/D fanout92/X VPWR VGND sg13g2_dfrbpq_1
X_452_ _617_/D _616_/Q _617_/Q _457_/S VPWR VGND sg13g2_mux2_1
X_383_ _548_/D _547_/Q _548_/Q _397_/S VPWR VGND sg13g2_mux2_1
XFILLER_45_414 VPWR VGND sg13g2_fill_1
XFILLER_12_1017 VPWR VGND sg13g2_decap_4
XFILLER_5_521 VPWR VGND sg13g2_decap_8
XFILLER_1_771 VPWR VGND sg13g2_decap_8
Xu_clkbuf_analog_pin0.u_buf analog_pin0 _316_/A1 VPWR VGND sg13g2_buf_16
XFILLER_5_587 VPWR VGND sg13g2_fill_1
XFILLER_0_270 VPWR VGND sg13g2_decap_4
XFILLER_49_786 VPWR VGND sg13g2_decap_8
XFILLER_46_767 VPWR VGND sg13g2_decap_8
X_504_ _504_/Q _677_/CLK _504_/D fanout85/X VPWR VGND sg13g2_dfrbpq_1
X_435_ _600_/D _599_/Q _600_/Q _442_/S VPWR VGND sg13g2_mux2_1
X_366_ _531_/D _530_/Q _531_/Q _455_/S VPWR VGND sg13g2_mux2_1
XFILLER_10_870 VPWR VGND sg13g2_decap_8
X_297_ _669_/D _635_/Q _649_/Q _306_/S VPWR VGND sg13g2_mux2_1
XFILLER_6_874 VPWR VGND sg13g2_decap_8
XFILLER_5_351 VPWR VGND sg13g2_decap_8
XFILLER_3_1004 VPWR VGND sg13g2_decap_8
Xclkbuf_5_18__f_clk_regs _647_/CLK clkbuf_4_9_0_clk_regs/X VPWR VGND sg13g2_buf_16
XFILLER_3_822 VPWR VGND sg13g2_decap_8
XFILLER_3_899 VPWR VGND sg13g2_decap_8
XFILLER_2_310 VPWR VGND sg13g2_decap_8
X_418_ _583_/D _582_/Q _583_/Q _419_/S VPWR VGND sg13g2_mux2_1
X_349_ _514_/D _513_/Q _514_/Q _407_/S VPWR VGND sg13g2_mux2_1
XFILLER_5_181 VPWR VGND sg13g2_fill_2
XFILLER_0_825 VPWR VGND sg13g2_decap_8
XFILLER_48_829 VPWR VGND sg13g2_fill_2
XFILLER_12_954 VPWR VGND sg13g2_decap_8
XFILLER_8_947 VPWR VGND sg13g2_decap_8
XFILLER_3_663 VPWR VGND sg13g2_fill_2
XFILLER_3_696 VPWR VGND sg13g2_decap_8
XFILLER_39_807 VPWR VGND sg13g2_decap_8
XFILLER_2_184 VPWR VGND sg13g2_fill_2
XFILLER_0_1007 VPWR VGND sg13g2_decap_8
XFILLER_0_65 VPWR VGND sg13g2_fill_2
XFILLER_9_1010 VPWR VGND sg13g2_decap_8
XFILLER_7_991 VPWR VGND sg13g2_decap_8
XFILLER_5_939 VPWR VGND sg13g2_decap_8
XFILLER_0_622 VPWR VGND sg13g2_decap_8
XFILLER_0_699 VPWR VGND sg13g2_decap_8
X_683_ _683_/Q _688_/CLK _683_/D fanout75/X VPWR VGND sg13g2_dfrbpq_1
XFILLER_26_821 VPWR VGND sg13g2_decap_8
XFILLER_5_714 VPWR VGND sg13g2_decap_8
XFILLER_1_953 VPWR VGND sg13g2_decap_8
Xclkbuf_regs_1_clk clkbuf_regs_1_clk/X _284_/Y VPWR VGND sg13g2_buf_16
XFILLER_4_279 VPWR VGND sg13g2_fill_1
XFILLER_0_463 VPWR VGND sg13g2_decap_4
XFILLER_0_485 VPWR VGND sg13g2_decap_8
XFILLER_17_821 VPWR VGND sg13g2_decap_8
X_597_ _597_/Q _601_/CLK _597_/D fanout99/X VPWR VGND sg13g2_dfrbpq_1
X_666_ _666_/Q _480_/Y _666_/D fanout70/X VPWR VGND sg13g2_dfrbpq_1
XANTENNA_2 ena VPWR VGND sg13g2_antennanp
XFILLER_2_717 VPWR VGND sg13g2_decap_8
X_520_ _520_/Q _633_/CLK _520_/D fanout90/X VPWR VGND sg13g2_dfrbpq_1
XFILLER_14_835 VPWR VGND sg13g2_decap_8
X_451_ _616_/D _615_/Q _616_/Q _464_/S VPWR VGND sg13g2_mux2_1
X_382_ _547_/D _546_/Q _547_/Q _398_/S VPWR VGND sg13g2_mux2_1
XFILLER_1_750 VPWR VGND sg13g2_decap_8
XFILLER_5_599 VPWR VGND sg13g2_decap_8
XFILLER_5_566 VPWR VGND sg13g2_decap_8
X_649_ _649_/Q _649_/CLK _649_/D fanout81/X VPWR VGND sg13g2_dfrbpq_1
XFILLER_49_765 VPWR VGND sg13g2_decap_8
Xclkbuf_5_17__f_clk_regs _648_/CLK clkbuf_4_8_0_clk_regs/X VPWR VGND sg13g2_buf_16
Xu_custom_cells.u_mux0.mux_inst VGND VPWR _316_/B2 _598_/Q _602_/Q _599_/Q mux
XFILLER_11_849 VPWR VGND sg13g2_decap_8
XFILLER_7_809 VPWR VGND sg13g2_decap_8
X_503_ _503_/Q _516_/CLK _503_/D fanout86/X VPWR VGND sg13g2_dfrbpq_1
X_434_ _599_/D _598_/Q _599_/Q _442_/S VPWR VGND sg13g2_mux2_1
X_365_ _530_/D _529_/Q _530_/Q _455_/S VPWR VGND sg13g2_mux2_1
X_296_ _668_/D _634_/Q _648_/Q _306_/S VPWR VGND sg13g2_mux2_1
XFILLER_6_853 VPWR VGND sg13g2_decap_8
XFILLER_5_396 VPWR VGND sg13g2_decap_8
XFILLER_47_27 VPWR VGND sg13g2_fill_1
XFILLER_28_779 VPWR VGND sg13g2_decap_8
XFILLER_3_801 VPWR VGND sg13g2_decap_8
XFILLER_3_878 VPWR VGND sg13g2_decap_8
XFILLER_19_779 VPWR VGND sg13g2_decap_8
X_417_ _582_/D _581_/Q _582_/Q _419_/S VPWR VGND sg13g2_mux2_1
X_348_ _513_/D _512_/Q _513_/Q _407_/S VPWR VGND sg13g2_mux2_1
X_279_ _279_/X _660_/Q _279_/B VPWR VGND sg13g2_and2_1
XFILLER_0_804 VPWR VGND sg13g2_decap_8
XFILLER_48_808 VPWR VGND sg13g2_decap_8
XFILLER_12_933 VPWR VGND sg13g2_decap_8
XFILLER_8_926 VPWR VGND sg13g2_decap_8
XFILLER_24_793 VPWR VGND sg13g2_decap_8
XFILLER_3_675 VPWR VGND sg13g2_decap_8
XFILLER_3_631 VPWR VGND sg13g2_fill_1
XFILLER_3_620 VPWR VGND sg13g2_decap_8
Xu_custom_cells.u_latmux.SwitchMatrixMultiplexer_inst _604_/Q VGND VPWR _316_/B2 _314_/B2
+ _310_/B2 _603_/Q SwitchMatrixMultiplexer
XFILLER_15_793 VPWR VGND sg13g2_decap_8
XFILLER_7_970 VPWR VGND sg13g2_decap_8
XFILLER_38_830 VPWR VGND sg13g2_decap_4
XFILLER_0_601 VPWR VGND sg13g2_decap_8
XFILLER_5_918 VPWR VGND sg13g2_decap_8
XFILLER_4_406 VPWR VGND sg13g2_fill_1
XFILLER_0_678 VPWR VGND sg13g2_decap_8
X_682_ _682_/Q _684_/CLK _682_/D fanout74/X VPWR VGND sg13g2_dfrbpq_1
XFILLER_44_833 VPWR VGND sg13g2_fill_2
XFILLER_4_995 VPWR VGND sg13g2_decap_8
XFILLER_26_800 VPWR VGND sg13g2_decap_8
XFILLER_4_203 VPWR VGND sg13g2_decap_8
XFILLER_1_932 VPWR VGND sg13g2_decap_8
XFILLER_17_800 VPWR VGND sg13g2_decap_8
X_665_ _665_/Q _479_/Y _665_/D fanout70/X VPWR VGND sg13g2_dfrbpq_1
X_596_ _596_/Q _596_/CLK _596_/D fanout97/X VPWR VGND sg13g2_dfrbpq_1
Xclkbuf_5_16__f_clk_regs _542_/CLK clkbuf_4_8_0_clk_regs/X VPWR VGND sg13g2_buf_16
XFILLER_32_825 VPWR VGND sg13g2_decap_4
XANTENNA_3 _687_/Q VPWR VGND sg13g2_antennanp
XFILLER_6_32 VPWR VGND sg13g2_fill_1
XFILLER_6_1014 VPWR VGND sg13g2_decap_8
XFILLER_4_792 VPWR VGND sg13g2_decap_8
XFILLER_23_814 VPWR VGND sg13g2_decap_8
XFILLER_14_814 VPWR VGND sg13g2_decap_8
X_450_ _615_/D _614_/Q _615_/Q _463_/S VPWR VGND sg13g2_mux2_1
X_381_ _546_/D _545_/Q _546_/Q _460_/S VPWR VGND sg13g2_mux2_1
X_648_ _648_/Q _648_/CLK _648_/D fanout82/X VPWR VGND sg13g2_dfrbpq_1
XFILLER_13_891 VPWR VGND sg13g2_decap_8
XFILLER_20_828 VPWR VGND sg13g2_decap_8
X_579_ _579_/Q _580_/CLK _579_/D fanout96/X VPWR VGND sg13g2_dfrbpq_1
XFILLER_9_884 VPWR VGND sg13g2_decap_8
XFILLER_11_828 VPWR VGND sg13g2_decap_8
Xdelaybuf_0_clk u_delay_line/clk _468_/B VPWR VGND sg13g2_buf_16
X_502_ _502_/Q _685_/CLK _502_/D fanout85/X VPWR VGND sg13g2_dfrbpq_1
X_433_ _598_/D _597_/Q _598_/Q _433_/S VPWR VGND sg13g2_mux2_1
X_364_ _529_/D _528_/Q _529_/Q _376_/S VPWR VGND sg13g2_mux2_1
X_295_ _667_/D _633_/Q _647_/Q _306_/S VPWR VGND sg13g2_mux2_1
XFILLER_6_832 VPWR VGND sg13g2_decap_8
XFILLER_3_857 VPWR VGND sg13g2_decap_8
XFILLER_2_334 VPWR VGND sg13g2_decap_8
X_416_ _581_/D _580_/Q _581_/Q _419_/S VPWR VGND sg13g2_mux2_1
X_347_ _512_/D _511_/Q _512_/Q _411_/S VPWR VGND sg13g2_mux2_1
X_278_ _278_/X _659_/Q _278_/B VPWR VGND sg13g2_and2_1
XFILLER_42_794 VPWR VGND sg13g2_decap_8
XFILLER_5_183 VPWR VGND sg13g2_fill_1
XFILLER_33_772 VPWR VGND sg13g2_fill_2
XFILLER_12_912 VPWR VGND sg13g2_decap_8
XFILLER_24_772 VPWR VGND sg13g2_decap_8
XFILLER_12_989 VPWR VGND sg13g2_decap_8
XFILLER_8_905 VPWR VGND sg13g2_decap_8
XFILLER_2_197 VPWR VGND sg13g2_decap_4
XFILLER_2_186 VPWR VGND sg13g2_fill_1
XFILLER_0_67 VPWR VGND sg13g2_fill_1
XFILLER_15_772 VPWR VGND sg13g2_decap_8
XFILLER_30_797 VPWR VGND sg13g2_decap_8
XFILLER_21_786 VPWR VGND sg13g2_decap_8
XFILLER_0_657 VPWR VGND sg13g2_decap_8
X_681_ _681_/Q _684_/CLK _681_/D fanout77/X VPWR VGND sg13g2_dfrbpq_1
XFILLER_44_812 VPWR VGND sg13g2_decap_8
Xclkbuf_5_15__f_clk_regs _685_/CLK clkbuf_4_7_0_clk_regs/X VPWR VGND sg13g2_buf_16
XFILLER_12_786 VPWR VGND sg13g2_decap_8
XFILLER_4_974 VPWR VGND sg13g2_decap_8
XFILLER_3_451 VPWR VGND sg13g2_fill_1
XFILLER_41_826 VPWR VGND sg13g2_decap_8
XFILLER_5_749 VPWR VGND sg13g2_decap_8
XFILLER_1_911 VPWR VGND sg13g2_decap_8
XFILLER_1_988 VPWR VGND sg13g2_decap_8
X_595_ _595_/Q _596_/CLK _595_/D fanout97/X VPWR VGND sg13g2_dfrbpq_1
X_664_ _664_/Q _478_/Y _664_/D fanout72/X VPWR VGND sg13g2_dfrbpq_1
XFILLER_32_804 VPWR VGND sg13g2_decap_8
XANTENNA_4 _283_/B VPWR VGND sg13g2_antennanp
XFILLER_4_771 VPWR VGND sg13g2_decap_8
Xclkbuf_4_12_0_clk_regs clkbuf_4_12_0_clk_regs/X clkbuf_0_clk_regs/X VPWR VGND sg13g2_buf_8
XFILLER_1_229 VPWR VGND sg13g2_decap_4
X_380_ _545_/D _544_/Q _545_/Q _460_/S VPWR VGND sg13g2_mux2_1
Xoutput30 uo_out[0] _308_/X VPWR VGND sg13g2_buf_1
XFILLER_5_535 VPWR VGND sg13g2_fill_2
XFILLER_1_785 VPWR VGND sg13g2_decap_8
XFILLER_20_807 VPWR VGND sg13g2_decap_8
X_578_ _578_/Q _580_/CLK _578_/D fanout96/X VPWR VGND sg13g2_dfrbpq_1
X_647_ _647_/Q _647_/CLK _647_/D fanout82/X VPWR VGND sg13g2_dfrbpq_1
XFILLER_13_870 VPWR VGND sg13g2_decap_8
XFILLER_9_863 VPWR VGND sg13g2_decap_8
.ends
